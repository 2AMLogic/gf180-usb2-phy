* extracted by klt lvs (deck gf180mcu)

* cell se_receiver_dm
* pin AMPOUT
* pin IBIASN
* pin VDD
* pin vsubs
.SUBCKT se_receiver_dm AMPOUT IBIASN VDD vsubs
* device instance $1 r0 *1 417.49,3.23 nfet
M$1 IBIASN IBIASN \$1 vsubs nfet L=0.5U W=4U AS=2P AD=2P PS=9U PD=9U
* device instance $2 r0 *1 422.92,3.23 nfet
M$2 \$8 AMPOUT \$1 vsubs nfet L=0.28U W=4U AS=2P AD=2P PS=9U PD=9U
* device instance $3 r0 *1 428.24,5.23 nfet
M$3 \$4 \$8 \$1 vsubs nfet L=0.28U W=8U AS=4P AD=4P PS=17U PD=17U
* device instance $4 r0 *1 468.07,5.23 nfet
M$4 \$3 IBIASN \$1 vsubs nfet L=0.5U W=8U AS=4P AD=4P PS=17U PD=17U
* device instance $5 r0 *1 433.77,11.23 nfet
M$5 \$5 \$15 \$3 vsubs nfet L=0.28U W=20U AS=10P AD=10P PS=41U PD=41U
* device instance $6 r0 *1 439.51,11.23 nfet
M$6 AMPOUT \$2 \$3 vsubs nfet L=0.28U W=20U AS=10P AD=10P PS=41U PD=41U
* device instance $7 r0 *1 445.24,5.23 pfet
M$7 \$8 AMPOUT VDD \$9 pfet L=0.28U W=8U AS=4P AD=4P PS=17U PD=17U
* device instance $8 r0 *1 450.96,9.23 pfet
M$8 \$4 \$8 VDD \$10 pfet L=0.28U W=16U AS=8P AD=8P PS=33U PD=33U
* device instance $9 r0 *1 456.69,21.23 pfet
M$9 \$5 \$5 VDD \$11 pfet L=0.28U W=40U AS=20P AD=20P PS=81U PD=81U
* device instance $10 r0 *1 462.43,21.23 pfet
M$10 AMPOUT \$5 VDD \$12 pfet L=0.28U W=40U AS=20P AD=20P PS=81U PD=81U
* device instance $11 r0 *1 2.42,1.22 ppolyf_u_1k
R$11 \$2 VDD vsubs 1900 ppolyf_u_1k
* device instance $12 r0 *1 8.76,1.22 ppolyf_u_1k
R$12 \$1 \$2 vsubs 1400 ppolyf_u_1k
* device instance $13 r0 *1 213.2,1.22 ppolyf_u_1k
R$13 IBIASN VDD vsubs 200000 ppolyf_u_1k
.ENDS se_receiver_dm
