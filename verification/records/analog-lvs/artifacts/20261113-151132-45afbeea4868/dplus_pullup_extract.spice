* extracted by klt extract --deck gf180mcu

* cell dplus_pullup
* pin DP
* pin NODE0
* pin NODE1
* pin NODE2
* pin NODE3
* pin NODE4
* pin NODE5
* pin PU_EN
* pin PU_ENB
* pin TRIM0
* pin TRIM0B
* pin TRIM1
* pin TRIM1B
* pin TRIM2
* pin TRIM2B
* pin TRIM3
* pin TRIM3B
* pin TRIM4
* pin TRIM4B
* pin vsubs
.SUBCKT dplus_pullup DP NODE0 NODE1 NODE2 NODE3 NODE4 NODE5 PU_EN PU_ENB TRIM0
+ TRIM0B TRIM1 TRIM1B TRIM2 TRIM2B TRIM3 TRIM3B TRIM4 TRIM4B vsubs
* device instance $1 r0 *1 0.64,1.73 nfet
M$1 PU_ENB PU_EN \$1 vsubs nfet L=0.28U W=1U AS=0.5P AD=0.5P PS=3U PD=3U
* device instance $2 r0 *1 13.68,1.73 nfet
M$2 TRIM0B TRIM0 \$1 vsubs nfet L=0.28U W=1U AS=0.5P AD=0.5P PS=3U PD=3U
* device instance $3 r0 *1 26.72,1.73 nfet
M$3 TRIM1B TRIM1 \$1 vsubs nfet L=0.28U W=1U AS=0.5P AD=0.5P PS=3U PD=3U
* device instance $4 r0 *1 39.76,1.73 nfet
M$4 TRIM2B TRIM2 \$1 vsubs nfet L=0.28U W=1U AS=0.5P AD=0.5P PS=3U PD=3U
* device instance $5 r0 *1 52.8,1.73 nfet
M$5 TRIM3B TRIM3 \$1 vsubs nfet L=0.28U W=1U AS=0.5P AD=0.5P PS=3U PD=3U
* device instance $6 r0 *1 65.84,1.73 nfet
M$6 TRIM4B TRIM4 \$1 vsubs nfet L=0.28U W=1U AS=0.5P AD=0.5P PS=3U PD=3U
* device instance $7 r0 *1 7.16,2.23 pfet
M$7 PU_ENB PU_EN \$2 \$6 pfet L=0.28U W=2U AS=1P AD=1P PS=5U PD=5U
* device instance $8 r0 *1 20.2,2.23 pfet
M$8 TRIM0B TRIM0 \$2 \$7 pfet L=0.28U W=2U AS=1P AD=1P PS=5U PD=5U
* device instance $9 r0 *1 33.24,2.23 pfet
M$9 TRIM1B TRIM1 \$2 \$8 pfet L=0.28U W=2U AS=1P AD=1P PS=5U PD=5U
* device instance $10 r0 *1 46.28,2.23 pfet
M$10 TRIM2B TRIM2 \$2 \$9 pfet L=0.28U W=2U AS=1P AD=1P PS=5U PD=5U
* device instance $11 r0 *1 59.32,2.23 pfet
M$11 TRIM3B TRIM3 \$2 \$10 pfet L=0.28U W=2U AS=1P AD=1P PS=5U PD=5U
* device instance $12 r0 *1 72.36,2.23 pfet
M$12 TRIM4B TRIM4 \$2 \$11 pfet L=0.28U W=2U AS=1P AD=1P PS=5U PD=5U
* device instance $13 r0 *1 79.09,51.23 pfet
M$13 NODE0 PU_ENB \$2 \$12 pfet L=0.28U W=100U AS=50P AD=50P PS=201U PD=201U
* device instance $14 r0 *1 80.77,51.23 pfet
M$14 NODE0 PU_ENB \$2 \$12 pfet L=0.28U W=100U AS=50P AD=50P PS=201U PD=201U
* device instance $15 r0 *1 82.45,51.23 pfet
M$15 NODE0 PU_ENB \$2 \$12 pfet L=0.28U W=100U AS=50P AD=50P PS=201U PD=201U
* device instance $16 r0 *1 84.13,51.23 pfet
M$16 NODE0 PU_ENB \$2 \$12 pfet L=0.28U W=100U AS=50P AD=50P PS=201U PD=201U
* device instance $17 r0 *1 85.81,51.23 pfet
M$17 NODE0 PU_ENB \$2 \$12 pfet L=0.28U W=100U AS=50P AD=50P PS=201U PD=201U
* device instance $18 r0 *1 87.49,51.23 pfet
M$18 NODE0 PU_ENB \$2 \$12 pfet L=0.28U W=100U AS=50P AD=50P PS=201U PD=201U
* device instance $19 r0 *1 89.17,51.23 pfet
M$19 NODE0 PU_ENB \$2 \$12 pfet L=0.28U W=100U AS=50P AD=50P PS=201U PD=201U
* device instance $20 r0 *1 90.85,51.23 pfet
M$20 NODE0 PU_ENB \$2 \$12 pfet L=0.28U W=100U AS=50P AD=50P PS=201U PD=201U
* device instance $21 r0 *1 92.53,51.23 pfet
M$21 NODE0 PU_ENB \$2 \$12 pfet L=0.28U W=100U AS=50P AD=50P PS=201U PD=201U
* device instance $22 r0 *1 94.21,51.23 pfet
M$22 NODE0 PU_ENB \$2 \$12 pfet L=0.28U W=100U AS=50P AD=50P PS=201U PD=201U
* device instance $23 r0 *1 120.88,51.23 pfet
M$23 NODE2 TRIM0B NODE1 \$16 pfet L=0.28U W=100U AS=50P AD=50P PS=201U PD=201U
* device instance $24 r0 *1 122.56,51.23 pfet
M$24 NODE2 TRIM0B NODE1 \$16 pfet L=0.28U W=100U AS=50P AD=50P PS=201U PD=201U
* device instance $25 r0 *1 124.24,51.23 pfet
M$25 NODE2 TRIM0B NODE1 \$16 pfet L=0.28U W=100U AS=50P AD=50P PS=201U PD=201U
* device instance $26 r0 *1 125.92,51.23 pfet
M$26 NODE2 TRIM0B NODE1 \$16 pfet L=0.28U W=100U AS=50P AD=50P PS=201U PD=201U
* device instance $27 r0 *1 127.6,51.23 pfet
M$27 NODE2 TRIM0B NODE1 \$16 pfet L=0.28U W=100U AS=50P AD=50P PS=201U PD=201U
* device instance $28 r0 *1 129.28,51.23 pfet
M$28 NODE2 TRIM0B NODE1 \$16 pfet L=0.28U W=100U AS=50P AD=50P PS=201U PD=201U
* device instance $29 r0 *1 130.96,51.23 pfet
M$29 NODE2 TRIM0B NODE1 \$16 pfet L=0.28U W=100U AS=50P AD=50P PS=201U PD=201U
* device instance $30 r0 *1 132.64,51.23 pfet
M$30 NODE2 TRIM0B NODE1 \$16 pfet L=0.28U W=100U AS=50P AD=50P PS=201U PD=201U
* device instance $31 r0 *1 134.32,51.23 pfet
M$31 NODE2 TRIM0B NODE1 \$16 pfet L=0.28U W=100U AS=50P AD=50P PS=201U PD=201U
* device instance $32 r0 *1 136,51.23 pfet
M$32 NODE2 TRIM0B NODE1 \$16 pfet L=0.28U W=100U AS=50P AD=50P PS=201U PD=201U
* device instance $33 r0 *1 147.465,51.23 pfet
M$33 NODE3 TRIM1B NODE2 \$17 pfet L=0.28U W=100U AS=50P AD=50P PS=201U PD=201U
* device instance $34 r0 *1 149.145,51.23 pfet
M$34 NODE3 TRIM1B NODE2 \$17 pfet L=0.28U W=100U AS=50P AD=50P PS=201U PD=201U
* device instance $35 r0 *1 150.825,51.23 pfet
M$35 NODE3 TRIM1B NODE2 \$17 pfet L=0.28U W=100U AS=50P AD=50P PS=201U PD=201U
* device instance $36 r0 *1 152.505,51.23 pfet
M$36 NODE3 TRIM1B NODE2 \$17 pfet L=0.28U W=100U AS=50P AD=50P PS=201U PD=201U
* device instance $37 r0 *1 154.185,51.23 pfet
M$37 NODE3 TRIM1B NODE2 \$17 pfet L=0.28U W=100U AS=50P AD=50P PS=201U PD=201U
* device instance $38 r0 *1 155.865,51.23 pfet
M$38 NODE3 TRIM1B NODE2 \$17 pfet L=0.28U W=100U AS=50P AD=50P PS=201U PD=201U
* device instance $39 r0 *1 157.545,51.23 pfet
M$39 NODE3 TRIM1B NODE2 \$17 pfet L=0.28U W=100U AS=50P AD=50P PS=201U PD=201U
* device instance $40 r0 *1 159.225,51.23 pfet
M$40 NODE3 TRIM1B NODE2 \$17 pfet L=0.28U W=100U AS=50P AD=50P PS=201U PD=201U
* device instance $41 r0 *1 160.905,51.23 pfet
M$41 NODE3 TRIM1B NODE2 \$17 pfet L=0.28U W=100U AS=50P AD=50P PS=201U PD=201U
* device instance $42 r0 *1 162.585,51.23 pfet
M$42 NODE3 TRIM1B NODE2 \$17 pfet L=0.28U W=100U AS=50P AD=50P PS=201U PD=201U
* device instance $43 r0 *1 174.735,51.23 pfet
M$43 NODE4 TRIM2B NODE3 \$18 pfet L=0.28U W=100U AS=50P AD=50P PS=201U PD=201U
* device instance $44 r0 *1 176.415,51.23 pfet
M$44 NODE4 TRIM2B NODE3 \$18 pfet L=0.28U W=100U AS=50P AD=50P PS=201U PD=201U
* device instance $45 r0 *1 178.095,51.23 pfet
M$45 NODE4 TRIM2B NODE3 \$18 pfet L=0.28U W=100U AS=50P AD=50P PS=201U PD=201U
* device instance $46 r0 *1 179.775,51.23 pfet
M$46 NODE4 TRIM2B NODE3 \$18 pfet L=0.28U W=100U AS=50P AD=50P PS=201U PD=201U
* device instance $47 r0 *1 181.455,51.23 pfet
M$47 NODE4 TRIM2B NODE3 \$18 pfet L=0.28U W=100U AS=50P AD=50P PS=201U PD=201U
* device instance $48 r0 *1 183.135,51.23 pfet
M$48 NODE4 TRIM2B NODE3 \$18 pfet L=0.28U W=100U AS=50P AD=50P PS=201U PD=201U
* device instance $49 r0 *1 184.815,51.23 pfet
M$49 NODE4 TRIM2B NODE3 \$18 pfet L=0.28U W=100U AS=50P AD=50P PS=201U PD=201U
* device instance $50 r0 *1 186.495,51.23 pfet
M$50 NODE4 TRIM2B NODE3 \$18 pfet L=0.28U W=100U AS=50P AD=50P PS=201U PD=201U
* device instance $51 r0 *1 188.175,51.23 pfet
M$51 NODE4 TRIM2B NODE3 \$18 pfet L=0.28U W=100U AS=50P AD=50P PS=201U PD=201U
* device instance $52 r0 *1 189.855,51.23 pfet
M$52 NODE4 TRIM2B NODE3 \$18 pfet L=0.28U W=100U AS=50P AD=50P PS=201U PD=201U
* device instance $53 r0 *1 203.38,51.23 pfet
M$53 NODE5 TRIM3B NODE4 \$19 pfet L=0.28U W=100U AS=50P AD=50P PS=201U PD=201U
* device instance $54 r0 *1 205.06,51.23 pfet
M$54 NODE5 TRIM3B NODE4 \$19 pfet L=0.28U W=100U AS=50P AD=50P PS=201U PD=201U
* device instance $55 r0 *1 206.74,51.23 pfet
M$55 NODE5 TRIM3B NODE4 \$19 pfet L=0.28U W=100U AS=50P AD=50P PS=201U PD=201U
* device instance $56 r0 *1 208.42,51.23 pfet
M$56 NODE5 TRIM3B NODE4 \$19 pfet L=0.28U W=100U AS=50P AD=50P PS=201U PD=201U
* device instance $57 r0 *1 210.1,51.23 pfet
M$57 NODE5 TRIM3B NODE4 \$19 pfet L=0.28U W=100U AS=50P AD=50P PS=201U PD=201U
* device instance $58 r0 *1 211.78,51.23 pfet
M$58 NODE5 TRIM3B NODE4 \$19 pfet L=0.28U W=100U AS=50P AD=50P PS=201U PD=201U
* device instance $59 r0 *1 213.46,51.23 pfet
M$59 NODE5 TRIM3B NODE4 \$19 pfet L=0.28U W=100U AS=50P AD=50P PS=201U PD=201U
* device instance $60 r0 *1 215.14,51.23 pfet
M$60 NODE5 TRIM3B NODE4 \$19 pfet L=0.28U W=100U AS=50P AD=50P PS=201U PD=201U
* device instance $61 r0 *1 216.82,51.23 pfet
M$61 NODE5 TRIM3B NODE4 \$19 pfet L=0.28U W=100U AS=50P AD=50P PS=201U PD=201U
* device instance $62 r0 *1 218.5,51.23 pfet
M$62 NODE5 TRIM3B NODE4 \$19 pfet L=0.28U W=100U AS=50P AD=50P PS=201U PD=201U
* device instance $63 r0 *1 234.765,51.23 pfet
M$63 DP TRIM4B NODE5 \$21 pfet L=0.28U W=100U AS=50P AD=50P PS=201U PD=201U
* device instance $64 r0 *1 236.445,51.23 pfet
M$64 DP TRIM4B NODE5 \$21 pfet L=0.28U W=100U AS=50P AD=50P PS=201U PD=201U
* device instance $65 r0 *1 238.125,51.23 pfet
M$65 DP TRIM4B NODE5 \$21 pfet L=0.28U W=100U AS=50P AD=50P PS=201U PD=201U
* device instance $66 r0 *1 239.805,51.23 pfet
M$66 DP TRIM4B NODE5 \$21 pfet L=0.28U W=100U AS=50P AD=50P PS=201U PD=201U
* device instance $67 r0 *1 241.485,51.23 pfet
M$67 DP TRIM4B NODE5 \$21 pfet L=0.28U W=100U AS=50P AD=50P PS=201U PD=201U
* device instance $68 r0 *1 243.165,51.23 pfet
M$68 DP TRIM4B NODE5 \$21 pfet L=0.28U W=100U AS=50P AD=50P PS=201U PD=201U
* device instance $69 r0 *1 244.845,51.23 pfet
M$69 DP TRIM4B NODE5 \$21 pfet L=0.28U W=100U AS=50P AD=50P PS=201U PD=201U
* device instance $70 r0 *1 246.525,51.23 pfet
M$70 DP TRIM4B NODE5 \$21 pfet L=0.28U W=100U AS=50P AD=50P PS=201U PD=201U
* device instance $71 r0 *1 248.205,51.23 pfet
M$71 DP TRIM4B NODE5 \$21 pfet L=0.28U W=100U AS=50P AD=50P PS=201U PD=201U
* device instance $72 r0 *1 249.885,51.23 pfet
M$72 DP TRIM4B NODE5 \$21 pfet L=0.28U W=100U AS=50P AD=50P PS=201U PD=201U
* device instance $73 r0 *1 105.315,2.22 ppolyf_u
X$73 NODE1 NODE0 vsubs ppolyf_u r=1000.125 L=11.43U W=4U
* device instance $74 r0 *1 115.28,2.22 ppolyf_u
X$74 NODE2 NODE1 vsubs ppolyf_u r=36.75 L=0.42U W=4U
* device instance $75 r0 *1 141.7325,2.22 ppolyf_u
X$75 NODE3 NODE2 vsubs ppolyf_u r=59.9375 L=0.685U W=4U
* device instance $76 r0 *1 168.66,2.22 ppolyf_u
X$76 NODE4 NODE3 vsubs ppolyf_u r=119.875 L=1.37U W=4U
* device instance $77 r0 *1 196.6175,2.22 ppolyf_u
X$77 NODE5 NODE4 vsubs ppolyf_u r=240.1875 L=2.745U W=4U
* device instance $78 r0 *1 226.6325,2.22 ppolyf_u
X$78 DP NODE5 vsubs ppolyf_u r=479.9375 L=5.485U W=4U
.ENDS dplus_pullup
