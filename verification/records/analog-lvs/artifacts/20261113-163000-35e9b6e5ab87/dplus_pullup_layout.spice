* extracted by klt lvs (deck gf180mcu)

* cell dplus_pullup
* pin DP
* pin PU_EN
* pin TRIM0
* pin TRIM1
* pin TRIM2
* pin TRIM3
* pin TRIM4
* pin VPU_REG
* pin VSS
.SUBCKT dplus_pullup DP PU_EN TRIM0 TRIM1 TRIM2 TRIM3 TRIM4 VPU_REG VSS
* device instance $1 r0 *1 0.64,1.73 nfet
M$1 \$16 PU_EN VSS VSS nfet L=0.28U W=1U AS=0.5P AD=0.5P PS=3U PD=3U
* device instance $2 r0 *1 13.68,1.73 nfet
M$2 \$17 TRIM0 VSS VSS nfet L=0.28U W=1U AS=0.5P AD=0.5P PS=3U PD=3U
* device instance $3 r0 *1 26.72,1.73 nfet
M$3 \$18 TRIM1 VSS VSS nfet L=0.28U W=1U AS=0.5P AD=0.5P PS=3U PD=3U
* device instance $4 r0 *1 39.76,1.73 nfet
M$4 \$19 TRIM2 VSS VSS nfet L=0.28U W=1U AS=0.5P AD=0.5P PS=3U PD=3U
* device instance $5 r0 *1 52.8,1.73 nfet
M$5 \$20 TRIM3 VSS VSS nfet L=0.28U W=1U AS=0.5P AD=0.5P PS=3U PD=3U
* device instance $6 r0 *1 65.84,1.73 nfet
M$6 \$21 TRIM4 VSS VSS nfet L=0.28U W=1U AS=0.5P AD=0.5P PS=3U PD=3U
* device instance $7 r0 *1 7.16,2.23 pfet
M$7 \$16 PU_EN VPU_REG VPU_REG pfet L=0.28U W=2U AS=1P AD=1P PS=5U PD=5U
* device instance $8 r0 *1 20.2,2.23 pfet
M$8 \$17 TRIM0 VPU_REG VPU_REG pfet L=0.28U W=2U AS=1P AD=1P PS=5U PD=5U
* device instance $9 r0 *1 33.24,2.23 pfet
M$9 \$18 TRIM1 VPU_REG VPU_REG pfet L=0.28U W=2U AS=1P AD=1P PS=5U PD=5U
* device instance $10 r0 *1 46.28,2.23 pfet
M$10 \$19 TRIM2 VPU_REG VPU_REG pfet L=0.28U W=2U AS=1P AD=1P PS=5U PD=5U
* device instance $11 r0 *1 59.32,2.23 pfet
M$11 \$20 TRIM3 VPU_REG VPU_REG pfet L=0.28U W=2U AS=1P AD=1P PS=5U PD=5U
* device instance $12 r0 *1 72.36,2.23 pfet
M$12 \$21 TRIM4 VPU_REG VPU_REG pfet L=0.28U W=2U AS=1P AD=1P PS=5U PD=5U
* device instance $13 r0 *1 79.09,51.23 pfet
M$13 \$5 \$16 VPU_REG VPU_REG pfet L=0.28U W=100U AS=50P AD=50P PS=201U PD=201U
* device instance $14 r0 *1 80.77,51.23 pfet
M$14 \$5 \$16 VPU_REG VPU_REG pfet L=0.28U W=100U AS=50P AD=50P PS=201U PD=201U
* device instance $15 r0 *1 82.45,51.23 pfet
M$15 \$5 \$16 VPU_REG VPU_REG pfet L=0.28U W=100U AS=50P AD=50P PS=201U PD=201U
* device instance $16 r0 *1 84.13,51.23 pfet
M$16 \$5 \$16 VPU_REG VPU_REG pfet L=0.28U W=100U AS=50P AD=50P PS=201U PD=201U
* device instance $17 r0 *1 85.81,51.23 pfet
M$17 \$5 \$16 VPU_REG VPU_REG pfet L=0.28U W=100U AS=50P AD=50P PS=201U PD=201U
* device instance $18 r0 *1 87.49,51.23 pfet
M$18 \$5 \$16 VPU_REG VPU_REG pfet L=0.28U W=100U AS=50P AD=50P PS=201U PD=201U
* device instance $19 r0 *1 89.17,51.23 pfet
M$19 \$5 \$16 VPU_REG VPU_REG pfet L=0.28U W=100U AS=50P AD=50P PS=201U PD=201U
* device instance $20 r0 *1 90.85,51.23 pfet
M$20 \$5 \$16 VPU_REG VPU_REG pfet L=0.28U W=100U AS=50P AD=50P PS=201U PD=201U
* device instance $21 r0 *1 92.53,51.23 pfet
M$21 \$5 \$16 VPU_REG VPU_REG pfet L=0.28U W=100U AS=50P AD=50P PS=201U PD=201U
* device instance $22 r0 *1 94.21,51.23 pfet
M$22 \$5 \$16 VPU_REG VPU_REG pfet L=0.28U W=100U AS=50P AD=50P PS=201U PD=201U
* device instance $23 r0 *1 120.88,51.23 pfet
M$23 \$7 \$17 \$6 VPU_REG pfet L=0.28U W=100U AS=50P AD=50P PS=201U PD=201U
* device instance $24 r0 *1 122.56,51.23 pfet
M$24 \$7 \$17 \$6 VPU_REG pfet L=0.28U W=100U AS=50P AD=50P PS=201U PD=201U
* device instance $25 r0 *1 124.24,51.23 pfet
M$25 \$7 \$17 \$6 VPU_REG pfet L=0.28U W=100U AS=50P AD=50P PS=201U PD=201U
* device instance $26 r0 *1 125.92,51.23 pfet
M$26 \$7 \$17 \$6 VPU_REG pfet L=0.28U W=100U AS=50P AD=50P PS=201U PD=201U
* device instance $27 r0 *1 127.6,51.23 pfet
M$27 \$7 \$17 \$6 VPU_REG pfet L=0.28U W=100U AS=50P AD=50P PS=201U PD=201U
* device instance $28 r0 *1 129.28,51.23 pfet
M$28 \$7 \$17 \$6 VPU_REG pfet L=0.28U W=100U AS=50P AD=50P PS=201U PD=201U
* device instance $29 r0 *1 130.96,51.23 pfet
M$29 \$7 \$17 \$6 VPU_REG pfet L=0.28U W=100U AS=50P AD=50P PS=201U PD=201U
* device instance $30 r0 *1 132.64,51.23 pfet
M$30 \$7 \$17 \$6 VPU_REG pfet L=0.28U W=100U AS=50P AD=50P PS=201U PD=201U
* device instance $31 r0 *1 134.32,51.23 pfet
M$31 \$7 \$17 \$6 VPU_REG pfet L=0.28U W=100U AS=50P AD=50P PS=201U PD=201U
* device instance $32 r0 *1 136,51.23 pfet
M$32 \$7 \$17 \$6 VPU_REG pfet L=0.28U W=100U AS=50P AD=50P PS=201U PD=201U
* device instance $33 r0 *1 147.465,51.23 pfet
M$33 \$8 \$18 \$7 VPU_REG pfet L=0.28U W=100U AS=50P AD=50P PS=201U PD=201U
* device instance $34 r0 *1 149.145,51.23 pfet
M$34 \$8 \$18 \$7 VPU_REG pfet L=0.28U W=100U AS=50P AD=50P PS=201U PD=201U
* device instance $35 r0 *1 150.825,51.23 pfet
M$35 \$8 \$18 \$7 VPU_REG pfet L=0.28U W=100U AS=50P AD=50P PS=201U PD=201U
* device instance $36 r0 *1 152.505,51.23 pfet
M$36 \$8 \$18 \$7 VPU_REG pfet L=0.28U W=100U AS=50P AD=50P PS=201U PD=201U
* device instance $37 r0 *1 154.185,51.23 pfet
M$37 \$8 \$18 \$7 VPU_REG pfet L=0.28U W=100U AS=50P AD=50P PS=201U PD=201U
* device instance $38 r0 *1 155.865,51.23 pfet
M$38 \$8 \$18 \$7 VPU_REG pfet L=0.28U W=100U AS=50P AD=50P PS=201U PD=201U
* device instance $39 r0 *1 157.545,51.23 pfet
M$39 \$8 \$18 \$7 VPU_REG pfet L=0.28U W=100U AS=50P AD=50P PS=201U PD=201U
* device instance $40 r0 *1 159.225,51.23 pfet
M$40 \$8 \$18 \$7 VPU_REG pfet L=0.28U W=100U AS=50P AD=50P PS=201U PD=201U
* device instance $41 r0 *1 160.905,51.23 pfet
M$41 \$8 \$18 \$7 VPU_REG pfet L=0.28U W=100U AS=50P AD=50P PS=201U PD=201U
* device instance $42 r0 *1 162.585,51.23 pfet
M$42 \$8 \$18 \$7 VPU_REG pfet L=0.28U W=100U AS=50P AD=50P PS=201U PD=201U
* device instance $43 r0 *1 174.735,51.23 pfet
M$43 \$3 \$19 \$8 VPU_REG pfet L=0.28U W=100U AS=50P AD=50P PS=201U PD=201U
* device instance $44 r0 *1 176.415,51.23 pfet
M$44 \$3 \$19 \$8 VPU_REG pfet L=0.28U W=100U AS=50P AD=50P PS=201U PD=201U
* device instance $45 r0 *1 178.095,51.23 pfet
M$45 \$3 \$19 \$8 VPU_REG pfet L=0.28U W=100U AS=50P AD=50P PS=201U PD=201U
* device instance $46 r0 *1 179.775,51.23 pfet
M$46 \$3 \$19 \$8 VPU_REG pfet L=0.28U W=100U AS=50P AD=50P PS=201U PD=201U
* device instance $47 r0 *1 181.455,51.23 pfet
M$47 \$3 \$19 \$8 VPU_REG pfet L=0.28U W=100U AS=50P AD=50P PS=201U PD=201U
* device instance $48 r0 *1 183.135,51.23 pfet
M$48 \$3 \$19 \$8 VPU_REG pfet L=0.28U W=100U AS=50P AD=50P PS=201U PD=201U
* device instance $49 r0 *1 184.815,51.23 pfet
M$49 \$3 \$19 \$8 VPU_REG pfet L=0.28U W=100U AS=50P AD=50P PS=201U PD=201U
* device instance $50 r0 *1 186.495,51.23 pfet
M$50 \$3 \$19 \$8 VPU_REG pfet L=0.28U W=100U AS=50P AD=50P PS=201U PD=201U
* device instance $51 r0 *1 188.175,51.23 pfet
M$51 \$3 \$19 \$8 VPU_REG pfet L=0.28U W=100U AS=50P AD=50P PS=201U PD=201U
* device instance $52 r0 *1 189.855,51.23 pfet
M$52 \$3 \$19 \$8 VPU_REG pfet L=0.28U W=100U AS=50P AD=50P PS=201U PD=201U
* device instance $53 r0 *1 203.38,51.23 pfet
M$53 \$4 \$20 \$3 VPU_REG pfet L=0.28U W=100U AS=50P AD=50P PS=201U PD=201U
* device instance $54 r0 *1 205.06,51.23 pfet
M$54 \$4 \$20 \$3 VPU_REG pfet L=0.28U W=100U AS=50P AD=50P PS=201U PD=201U
* device instance $55 r0 *1 206.74,51.23 pfet
M$55 \$4 \$20 \$3 VPU_REG pfet L=0.28U W=100U AS=50P AD=50P PS=201U PD=201U
* device instance $56 r0 *1 208.42,51.23 pfet
M$56 \$4 \$20 \$3 VPU_REG pfet L=0.28U W=100U AS=50P AD=50P PS=201U PD=201U
* device instance $57 r0 *1 210.1,51.23 pfet
M$57 \$4 \$20 \$3 VPU_REG pfet L=0.28U W=100U AS=50P AD=50P PS=201U PD=201U
* device instance $58 r0 *1 211.78,51.23 pfet
M$58 \$4 \$20 \$3 VPU_REG pfet L=0.28U W=100U AS=50P AD=50P PS=201U PD=201U
* device instance $59 r0 *1 213.46,51.23 pfet
M$59 \$4 \$20 \$3 VPU_REG pfet L=0.28U W=100U AS=50P AD=50P PS=201U PD=201U
* device instance $60 r0 *1 215.14,51.23 pfet
M$60 \$4 \$20 \$3 VPU_REG pfet L=0.28U W=100U AS=50P AD=50P PS=201U PD=201U
* device instance $61 r0 *1 216.82,51.23 pfet
M$61 \$4 \$20 \$3 VPU_REG pfet L=0.28U W=100U AS=50P AD=50P PS=201U PD=201U
* device instance $62 r0 *1 218.5,51.23 pfet
M$62 \$4 \$20 \$3 VPU_REG pfet L=0.28U W=100U AS=50P AD=50P PS=201U PD=201U
* device instance $63 r0 *1 234.765,51.23 pfet
M$63 DP \$21 \$4 VPU_REG pfet L=0.28U W=100U AS=50P AD=50P PS=201U PD=201U
* device instance $64 r0 *1 236.445,51.23 pfet
M$64 DP \$21 \$4 VPU_REG pfet L=0.28U W=100U AS=50P AD=50P PS=201U PD=201U
* device instance $65 r0 *1 238.125,51.23 pfet
M$65 DP \$21 \$4 VPU_REG pfet L=0.28U W=100U AS=50P AD=50P PS=201U PD=201U
* device instance $66 r0 *1 239.805,51.23 pfet
M$66 DP \$21 \$4 VPU_REG pfet L=0.28U W=100U AS=50P AD=50P PS=201U PD=201U
* device instance $67 r0 *1 241.485,51.23 pfet
M$67 DP \$21 \$4 VPU_REG pfet L=0.28U W=100U AS=50P AD=50P PS=201U PD=201U
* device instance $68 r0 *1 243.165,51.23 pfet
M$68 DP \$21 \$4 VPU_REG pfet L=0.28U W=100U AS=50P AD=50P PS=201U PD=201U
* device instance $69 r0 *1 244.845,51.23 pfet
M$69 DP \$21 \$4 VPU_REG pfet L=0.28U W=100U AS=50P AD=50P PS=201U PD=201U
* device instance $70 r0 *1 246.525,51.23 pfet
M$70 DP \$21 \$4 VPU_REG pfet L=0.28U W=100U AS=50P AD=50P PS=201U PD=201U
* device instance $71 r0 *1 248.205,51.23 pfet
M$71 DP \$21 \$4 VPU_REG pfet L=0.28U W=100U AS=50P AD=50P PS=201U PD=201U
* device instance $72 r0 *1 249.885,51.23 pfet
M$72 DP \$21 \$4 VPU_REG pfet L=0.28U W=100U AS=50P AD=50P PS=201U PD=201U
* device instance $73 r0 *1 105.315,2.22 ppolyf_u
R$73 \$6 \$5 VSS 1000.125 ppolyf_u
* device instance $74 r0 *1 115.28,2.22 ppolyf_u
R$74 \$7 \$6 VSS 36.75 ppolyf_u
* device instance $75 r0 *1 141.7325,2.22 ppolyf_u
R$75 \$8 \$7 VSS 59.9375 ppolyf_u
* device instance $76 r0 *1 168.66,2.22 ppolyf_u
R$76 \$3 \$8 VSS 119.875 ppolyf_u
* device instance $77 r0 *1 196.6175,2.22 ppolyf_u
R$77 \$4 \$3 VSS 240.1875 ppolyf_u
* device instance $78 r0 *1 226.6325,2.22 ppolyf_u
R$78 DP \$4 VSS 479.9375 ppolyf_u
.ENDS dplus_pullup
