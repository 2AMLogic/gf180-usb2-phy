* extracted by klt extract --deck gf180mcu

* cell differential_receiver
* pin DM
* pin DP
* pin RXD
* pin VDD
* pin VSS
.SUBCKT differential_receiver DM DP RXD VDD VSS
* device instance $1 r0 *1 410.24,2.23 nfet
M$1 \$6 \$8 VSS VSS nfet L=0.28U W=2U AS=1P AD=1P PS=5U PD=5U
* device instance $2 r0 *1 404.81,3.23 nfet
M$2 \$5 \$5 VSS VSS nfet L=0.5U W=4U AS=2P AD=2P PS=9U PD=9U
* device instance $3 r0 *1 415.56,5.23 nfet
M$3 RXD \$6 VSS VSS nfet L=0.28U W=8U AS=4P AD=4P PS=17U PD=17U
* device instance $4 r0 *1 455.41,5.23 nfet
M$4 \$4 \$5 VSS VSS nfet L=0.5U W=8U AS=4P AD=4P PS=17U PD=17U
* device instance $5 r0 *1 421.09,11.23 nfet
M$5 \$7 DP \$4 VSS nfet L=0.28U W=20U AS=10P AD=10P PS=41U PD=41U
* device instance $6 r0 *1 426.83,11.23 nfet
M$6 \$8 DM \$4 VSS nfet L=0.28U W=20U AS=10P AD=10P PS=41U PD=41U
* device instance $7 r0 *1 438.3,9.23 pfet
M$7 RXD \$6 VDD VDD pfet L=0.28U W=16U AS=8P AD=8P PS=33U PD=33U
* device instance $8 r0 *1 432.57,17.23 pfet
M$8 \$6 \$8 VDD VDD pfet L=0.28U W=32U AS=16P AD=16P PS=65U PD=65U
* device instance $9 r0 *1 444.03,21.23 pfet
M$9 \$7 \$7 VDD VDD pfet L=0.28U W=40U AS=20P AD=20P PS=81U PD=81U
* device instance $10 r0 *1 449.77,21.23 pfet
M$10 \$8 \$7 VDD VDD pfet L=0.28U W=40U AS=20P AD=20P PS=81U PD=81U
* device instance $11 r0 *1 200.52,1.22 ppolyf_u_1k
X$11 \$5 VDD VSS ppolyf_u_1k r=200000 L=400U W=2U
.ENDS differential_receiver
