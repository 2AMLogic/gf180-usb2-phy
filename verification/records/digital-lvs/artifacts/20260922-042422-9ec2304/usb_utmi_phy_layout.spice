* extracted by klt extract --deck gf180mcu

* cell usb_utmi_phy
* pin DataIn[0]
* pin DataIn[1]
* pin DataIn[2]
* pin DataIn[3]
* pin DataIn[4]
* pin DataIn[5]
* pin DataIn[6]
* pin DataIn[7]
* pin DataOut[0]
* pin DataOut[1]
* pin DataOut[2]
* pin DataOut[3]
* pin DataOut[4]
* pin DataOut[5]
* pin DataOut[6]
* pin DataOut[7]
* pin OpMode[0]
* pin OpMode[1]
* pin Reset
* pin RxError
* pin RxValid
* pin TxReady
* pin TxValid
* pin VDD
* pin VSS
* pin clk
* pin line_state[0]
* pin line_state[1]
* pin rst_n
* pin rx_receiving
* pin rxdm
* pin rxdp
* pin txdm
* pin txdp
* pin SuspendM
* pin TermSelect
* pin XcvrSelect
.SUBCKT usb_utmi_phy DataIn[0] DataIn[1] DataIn[2] DataIn[3] DataIn[4]
+ DataIn[5] DataIn[6] DataIn[7] DataOut[0] DataOut[1] DataOut[2] DataOut[3]
+ DataOut[4] DataOut[5] DataOut[6] DataOut[7] OpMode[0] OpMode[1] Reset RxError
+ RxValid TxReady TxValid VDD VSS clk line_state[0] line_state[1] rst_n
+ rx_receiving rxdm rxdp txdm txdp SuspendM TermSelect XcvrSelect
* cell instance gf180mcu_fd_sc_mcu9t5v0__and2_1_0 r0 *1 0,0
Xgf180mcu_fd_sc_mcu9t5v0__and2_1_0 u_sync_detector/match[0] dec_data_strobe VDD
+ VSS u_sync_detector/_13_ gf180mcu_fd_sc_mcu9t5v0__and2_1
* cell instance gf180mcu_fd_sc_mcu9t5v0__and2_1_1 r0 *1 0,0
Xgf180mcu_fd_sc_mcu9t5v0__and2_1_1 rx_stuff_err \_017_ VDD VSS \_045_
+ gf180mcu_fd_sc_mcu9t5v0__and2_1
* cell instance gf180mcu_fd_sc_mcu9t5v0__and2_1_2 r0 *1 0,0
Xgf180mcu_fd_sc_mcu9t5v0__and2_1_2 u_eop_detector/_12_ u_eop_detector/_26_ VDD
+ VSS u_eop_detector/_07_ gf180mcu_fd_sc_mcu9t5v0__and2_1
* cell instance gf180mcu_fd_sc_mcu9t5v0__and2_1_3 r0 *1 0,0
Xgf180mcu_fd_sc_mcu9t5v0__and2_1_3 tx_state[1] \_053_ VDD VSS \_001_
+ gf180mcu_fd_sc_mcu9t5v0__and2_1
* cell instance gf180mcu_fd_sc_mcu9t5v0__and2_1_4 r0 *1 0,0
Xgf180mcu_fd_sc_mcu9t5v0__and2_1_4 tx_state[5] \_053_ VDD VSS \_000_
+ gf180mcu_fd_sc_mcu9t5v0__and2_1
* cell instance gf180mcu_fd_sc_mcu9t5v0__and2_1_5 r0 *1 0,0
Xgf180mcu_fd_sc_mcu9t5v0__and2_1_5 tx_state[3] \_053_ VDD VSS \_003_
+ gf180mcu_fd_sc_mcu9t5v0__and2_1
* cell instance gf180mcu_fd_sc_mcu9t5v0__and2_1_6 r0 *1 0,0
Xgf180mcu_fd_sc_mcu9t5v0__and2_1_6 \_012_ stuff_consume VDD VSS stuff_bit_out
+ gf180mcu_fd_sc_mcu9t5v0__and2_1
* cell instance gf180mcu_fd_sc_mcu9t5v0__and2_1_7 r0 *1 0,0
Xgf180mcu_fd_sc_mcu9t5v0__and2_1_7 \_053_ \_125_ VDD VSS \_031_
+ gf180mcu_fd_sc_mcu9t5v0__and2_1
* cell instance gf180mcu_fd_sc_mcu9t5v0__and2_1_8 r0 *1 0,0
Xgf180mcu_fd_sc_mcu9t5v0__and2_1_8 \_121_ \_122_ VDD VSS \_029_
+ gf180mcu_fd_sc_mcu9t5v0__and2_1
* cell instance gf180mcu_fd_sc_mcu9t5v0__and2_1_9 r0 *1 0,0
Xgf180mcu_fd_sc_mcu9t5v0__and2_1_9 sync_idx[0] \_119_ VDD VSS \_120_
+ gf180mcu_fd_sc_mcu9t5v0__and2_1
* cell instance gf180mcu_fd_sc_mcu9t5v0__and2_2_0 r0 *1 0,0
Xgf180mcu_fd_sc_mcu9t5v0__and2_2_0 u_sync_detector/match[2]
+ u_sync_detector/_10_ VDD VSS u_sync_detector/_11_
+ gf180mcu_fd_sc_mcu9t5v0__and2_2
* cell instance gf180mcu_fd_sc_mcu9t5v0__and2_2_1 r0 *1 0,0
Xgf180mcu_fd_sc_mcu9t5v0__and2_2_1 \_053_ sync_next VDD VSS
+ u_sync_detector/_04_ gf180mcu_fd_sc_mcu9t5v0__and2_2
* cell instance gf180mcu_fd_sc_mcu9t5v0__and2_4_0 r0 *1 0,0
Xgf180mcu_fd_sc_mcu9t5v0__and2_4_0 rx_bit_valid rx_assembly_en VDD VSS \_086_
+ gf180mcu_fd_sc_mcu9t5v0__and2_4
* cell instance gf180mcu_fd_sc_mcu9t5v0__and2_4_1 r0 *1 0,0
Xgf180mcu_fd_sc_mcu9t5v0__and2_4_1 \_053_ rxdm VDD VSS u_line_state/_1_
+ gf180mcu_fd_sc_mcu9t5v0__and2_4
* cell instance gf180mcu_fd_sc_mcu9t5v0__and3_1_0 r0 *1 0,0
Xgf180mcu_fd_sc_mcu9t5v0__and3_1_0 u_eop_detector/se0_count[3]
+ u_eop_detector/se0_count[2] u_eop_detector/_15_ VDD VSS u_eop_detector/_24_
+ gf180mcu_fd_sc_mcu9t5v0__and3_1
* cell instance gf180mcu_fd_sc_mcu9t5v0__and3_1_1 r0 *1 0,0
Xgf180mcu_fd_sc_mcu9t5v0__and3_1_1 sync_idx[0] sync_idx[2] sync_idx[1] VDD VSS
+ \_063_ gf180mcu_fd_sc_mcu9t5v0__and3_1
* cell instance gf180mcu_fd_sc_mcu9t5v0__and3_2_0 r0 *1 0,0
Xgf180mcu_fd_sc_mcu9t5v0__and3_2_0 u_sync_detector/match[0] dec_data_strobe
+ u_sync_detector/match[1] VDD VSS u_sync_detector/_10_
+ gf180mcu_fd_sc_mcu9t5v0__and3_2
* cell instance gf180mcu_fd_sc_mcu9t5v0__and3_2_1 r0 *1 0,0
Xgf180mcu_fd_sc_mcu9t5v0__and3_2_1 rx_receiving dec_data_bit u_destuffer/_06_
+ VDD VSS u_destuffer/_09_ gf180mcu_fd_sc_mcu9t5v0__and3_2
* cell instance gf180mcu_fd_sc_mcu9t5v0__and3_4_0 r0 *1 0,0
Xgf180mcu_fd_sc_mcu9t5v0__and3_4_0 rx_bitcnt[1] rx_bitcnt[0] \_086_ VDD VSS
+ \_095_ gf180mcu_fd_sc_mcu9t5v0__and3_4
* cell instance gf180mcu_fd_sc_mcu9t5v0__and3_4_1 r0 *1 0,0
Xgf180mcu_fd_sc_mcu9t5v0__and3_4_1 u_eop_detector/se0_count[3]
+ u_eop_detector/se0_count[4] u_eop_detector/se0_count[2] VDD VSS
+ u_eop_detector/_10_ gf180mcu_fd_sc_mcu9t5v0__and3_4
* cell instance gf180mcu_fd_sc_mcu9t5v0__and4_1_0 r0 *1 0,0
Xgf180mcu_fd_sc_mcu9t5v0__and4_1_0 dec_data_strobe rx_receiving dec_data_bit
+ u_destuffer/_07_ VDD VSS u_destuffer/_01_ gf180mcu_fd_sc_mcu9t5v0__and4_1
* cell instance gf180mcu_fd_sc_mcu9t5v0__and4_4_0 r0 *1 0,0
Xgf180mcu_fd_sc_mcu9t5v0__and4_4_0 rx_receiving rx_bitcnt[2] \_053_ \_095_ VDD
+ VSS \_096_ gf180mcu_fd_sc_mcu9t5v0__and4_4
* cell instance gf180mcu_fd_sc_mcu9t5v0__aoi211_1_0 r0 *1 0,0
Xgf180mcu_fd_sc_mcu9t5v0__aoi211_1_0 u_sync_detector/_06_ u_sync_detector/_13_
+ u_sync_detector/_15_ u_sync_detector/_09_ VDD VSS u_sync_detector/_03_
+ gf180mcu_fd_sc_mcu9t5v0__aoi211_1
* cell instance gf180mcu_fd_sc_mcu9t5v0__aoi211_1_1 r0 *1 0,0
Xgf180mcu_fd_sc_mcu9t5v0__aoi211_1_1 u_eop_detector/_14_ u_eop_detector/_18_
+ u_eop_detector/_15_ u_eop_detector/_09_ VDD VSS u_eop_detector/_02_
+ gf180mcu_fd_sc_mcu9t5v0__aoi211_1
* cell instance gf180mcu_fd_sc_mcu9t5v0__aoi211_1_2 r0 *1 0,0
Xgf180mcu_fd_sc_mcu9t5v0__aoi211_1_2 \_099_ \_092_ \_100_ \_052_ VDD VSS \_019_
+ gf180mcu_fd_sc_mcu9t5v0__aoi211_1
* cell instance gf180mcu_fd_sc_mcu9t5v0__aoi211_1_3 r0 *1 0,0
Xgf180mcu_fd_sc_mcu9t5v0__aoi211_1_3 \_097_ \_092_ \_098_ \_052_ VDD VSS \_018_
+ gf180mcu_fd_sc_mcu9t5v0__aoi211_1
* cell instance gf180mcu_fd_sc_mcu9t5v0__aoi211_1_4 r0 *1 0,0
Xgf180mcu_fd_sc_mcu9t5v0__aoi211_1_4 \_107_ \_092_ \_108_ \_052_ VDD VSS \_023_
+ gf180mcu_fd_sc_mcu9t5v0__aoi211_1
* cell instance gf180mcu_fd_sc_mcu9t5v0__aoi211_1_5 r0 *1 0,0
Xgf180mcu_fd_sc_mcu9t5v0__aoi211_1_5 \_109_ \_092_ \_110_ \_052_ VDD VSS \_024_
+ gf180mcu_fd_sc_mcu9t5v0__aoi211_1
* cell instance gf180mcu_fd_sc_mcu9t5v0__aoi211_1_6 r0 *1 0,0
Xgf180mcu_fd_sc_mcu9t5v0__aoi211_1_6 \_090_ \_092_ \_094_ \_052_ VDD VSS \_015_
+ gf180mcu_fd_sc_mcu9t5v0__aoi211_1
* cell instance gf180mcu_fd_sc_mcu9t5v0__aoi211_1_7 r0 *1 0,0
Xgf180mcu_fd_sc_mcu9t5v0__aoi211_1_7 \_129_ \_092_ \_130_ \_052_ VDD VSS \_038_
+ gf180mcu_fd_sc_mcu9t5v0__aoi211_1
* cell instance gf180mcu_fd_sc_mcu9t5v0__aoi211_1_8 r0 *1 0,0
Xgf180mcu_fd_sc_mcu9t5v0__aoi211_1_8 \_101_ \_092_ \_102_ \_052_ VDD VSS \_020_
+ gf180mcu_fd_sc_mcu9t5v0__aoi211_1
* cell instance gf180mcu_fd_sc_mcu9t5v0__aoi211_1_9 r0 *1 0,0
Xgf180mcu_fd_sc_mcu9t5v0__aoi211_1_9 \_064_ \_119_ \_123_ \_052_ VDD VSS \_030_
+ gf180mcu_fd_sc_mcu9t5v0__aoi211_1
* cell instance gf180mcu_fd_sc_mcu9t5v0__aoi211_1_10 r0 *1 0,0
Xgf180mcu_fd_sc_mcu9t5v0__aoi211_1_10 \_080_ \_134_ \_142_ \_052_ VDD VSS
+ \_047_ gf180mcu_fd_sc_mcu9t5v0__aoi211_1
* cell instance gf180mcu_fd_sc_mcu9t5v0__aoi211_1_11 r0 *1 0,0
Xgf180mcu_fd_sc_mcu9t5v0__aoi211_1_11 \_132_ \_143_ \_144_ \_052_ VDD VSS
+ \_048_ gf180mcu_fd_sc_mcu9t5v0__aoi211_1
* cell instance gf180mcu_fd_sc_mcu9t5v0__aoi211_1_12 r0 *1 0,0
Xgf180mcu_fd_sc_mcu9t5v0__aoi211_1_12 \_105_ \_092_ \_106_ \_052_ VDD VSS
+ \_022_ gf180mcu_fd_sc_mcu9t5v0__aoi211_1
* cell instance gf180mcu_fd_sc_mcu9t5v0__aoi211_1_13 r0 *1 0,0
Xgf180mcu_fd_sc_mcu9t5v0__aoi211_1_13 tx_state[4] \_120_ \_126_ \_052_ VDD VSS
+ \_032_ gf180mcu_fd_sc_mcu9t5v0__aoi211_1
* cell instance gf180mcu_fd_sc_mcu9t5v0__aoi211_2_0 r0 *1 0,0
Xgf180mcu_fd_sc_mcu9t5v0__aoi211_2_0 \_131_ \_135_ \_137_ \_052_ VDD VSS \_040_
+ gf180mcu_fd_sc_mcu9t5v0__aoi211_2
* cell instance gf180mcu_fd_sc_mcu9t5v0__aoi21_1_0 r0 *1 0,0
Xgf180mcu_fd_sc_mcu9t5v0__aoi21_1_0 rx_bitcnt[0] \_086_ rx_bitcnt[1] VDD VSS
+ \_145_ gf180mcu_fd_sc_mcu9t5v0__aoi21_1
* cell instance gf180mcu_fd_sc_mcu9t5v0__aoi21_1_1 r0 *1 0,0
Xgf180mcu_fd_sc_mcu9t5v0__aoi21_1_1 \_115_ \_116_ \_089_ VDD VSS \_027_
+ gf180mcu_fd_sc_mcu9t5v0__aoi21_1
* cell instance gf180mcu_fd_sc_mcu9t5v0__aoi21_1_2 r0 *1 0,0
Xgf180mcu_fd_sc_mcu9t5v0__aoi21_1_2 \_117_ \_118_ \_089_ VDD VSS \_028_
+ gf180mcu_fd_sc_mcu9t5v0__aoi21_1
* cell instance gf180mcu_fd_sc_mcu9t5v0__aoi21_1_3 r0 *1 0,0
Xgf180mcu_fd_sc_mcu9t5v0__aoi21_1_3 u_destuffer/ones_run[1] u_destuffer/_12_
+ u_destuffer/ones_run[2] VDD VSS u_destuffer/_14_
+ gf180mcu_fd_sc_mcu9t5v0__aoi21_1
* cell instance gf180mcu_fd_sc_mcu9t5v0__aoi21_1_4 r0 *1 0,0
Xgf180mcu_fd_sc_mcu9t5v0__aoi21_1_4 \_113_ \_114_ \_089_ VDD VSS \_026_
+ gf180mcu_fd_sc_mcu9t5v0__aoi21_1
* cell instance gf180mcu_fd_sc_mcu9t5v0__aoi21_1_5 r0 *1 0,0
Xgf180mcu_fd_sc_mcu9t5v0__aoi21_1_5 dec_data_strobe u_destuffer/_09_
+ u_destuffer/ones_run[0] VDD VSS u_destuffer/_15_
+ gf180mcu_fd_sc_mcu9t5v0__aoi21_1
* cell instance gf180mcu_fd_sc_mcu9t5v0__aoi21_1_6 r0 *1 0,0
Xgf180mcu_fd_sc_mcu9t5v0__aoi21_1_6 rx_bitcnt[2] \_095_ \_128_ VDD VSS \_036_
+ gf180mcu_fd_sc_mcu9t5v0__aoi21_1
* cell instance gf180mcu_fd_sc_mcu9t5v0__aoi21_1_7 r0 *1 0,0
Xgf180mcu_fd_sc_mcu9t5v0__aoi21_1_7 \_111_ \_112_ \_089_ VDD VSS \_025_
+ gf180mcu_fd_sc_mcu9t5v0__aoi21_1
* cell instance gf180mcu_fd_sc_mcu9t5v0__aoi21_1_8 r0 *1 0,0
Xgf180mcu_fd_sc_mcu9t5v0__aoi21_1_8 u_eop_detector/_22_ u_eop_detector/_23_
+ u_eop_detector/_09_ VDD VSS u_eop_detector/_04_
+ gf180mcu_fd_sc_mcu9t5v0__aoi21_1
* cell instance gf180mcu_fd_sc_mcu9t5v0__aoi21_1_9 r0 *1 0,0
Xgf180mcu_fd_sc_mcu9t5v0__aoi21_1_9 \_103_ \_104_ \_089_ VDD VSS \_021_
+ gf180mcu_fd_sc_mcu9t5v0__aoi21_1
* cell instance gf180mcu_fd_sc_mcu9t5v0__aoi21_1_10 r0 *1 0,0
Xgf180mcu_fd_sc_mcu9t5v0__aoi21_1_10 \_085_ \_088_ \_089_ VDD VSS \_014_
+ gf180mcu_fd_sc_mcu9t5v0__aoi21_1
* cell instance gf180mcu_fd_sc_mcu9t5v0__aoi21_1_11 r0 *1 0,0
Xgf180mcu_fd_sc_mcu9t5v0__aoi21_1_11 \_146_ \_147_ \_089_ VDD VSS \_050_
+ gf180mcu_fd_sc_mcu9t5v0__aoi21_1
* cell instance gf180mcu_fd_sc_mcu9t5v0__aoi21_1_12 r0 *1 0,0
Xgf180mcu_fd_sc_mcu9t5v0__aoi21_1_12 u_eop_detector/se0_count[2]
+ u_eop_detector/_15_ u_eop_detector/se0_count[3] VDD VSS u_eop_detector/_25_
+ gf180mcu_fd_sc_mcu9t5v0__aoi21_1
* cell instance gf180mcu_fd_sc_mcu9t5v0__aoi21_1_13 r0 *1 0,0
Xgf180mcu_fd_sc_mcu9t5v0__aoi21_1_13 u_eop_detector/_10_ u_eop_detector/_12_
+ bus_reset VDD VSS u_eop_detector/_13_ gf180mcu_fd_sc_mcu9t5v0__aoi21_1
* cell instance gf180mcu_fd_sc_mcu9t5v0__aoi21_1_14 r0 *1 0,0
Xgf180mcu_fd_sc_mcu9t5v0__aoi21_1_14 u_eop_detector/se0_count[1]
+ u_eop_detector/_10_ u_eop_detector/_18_ VDD VSS u_eop_detector/_19_
+ gf180mcu_fd_sc_mcu9t5v0__aoi21_1
* cell instance gf180mcu_fd_sc_mcu9t5v0__aoi21_1_15 r0 *1 0,0
Xgf180mcu_fd_sc_mcu9t5v0__aoi21_1_15 u_eop_detector/_17_ u_eop_detector/_20_
+ u_eop_detector/se0_count[0] VDD VSS u_eop_detector/_21_
+ gf180mcu_fd_sc_mcu9t5v0__aoi21_1
* cell instance gf180mcu_fd_sc_mcu9t5v0__aoi21_1_16 r0 *1 0,0
Xgf180mcu_fd_sc_mcu9t5v0__aoi21_1_16 \_079_ \_082_ tx_state[6] VDD VSS \_012_
+ gf180mcu_fd_sc_mcu9t5v0__aoi21_1
* cell instance gf180mcu_fd_sc_mcu9t5v0__aoi21_1_17 r0 *1 0,0
Xgf180mcu_fd_sc_mcu9t5v0__aoi21_1_17 \_061_ \_064_ \_052_ VDD VSS \_007_
+ gf180mcu_fd_sc_mcu9t5v0__aoi21_1
* cell instance gf180mcu_fd_sc_mcu9t5v0__aoi21_1_18 r0 *1 0,0
Xgf180mcu_fd_sc_mcu9t5v0__aoi21_1_18 \_073_ \_075_ \_052_ VDD VSS \_006_
+ gf180mcu_fd_sc_mcu9t5v0__aoi21_1
* cell instance gf180mcu_fd_sc_mcu9t5v0__aoi21_1_19 r0 *1 0,0
Xgf180mcu_fd_sc_mcu9t5v0__aoi21_1_19 sync_idx[1] \_120_ sync_idx[2] VDD VSS
+ \_123_ gf180mcu_fd_sc_mcu9t5v0__aoi21_1
* cell instance gf180mcu_fd_sc_mcu9t5v0__aoi21_1_20 r0 *1 0,0
Xgf180mcu_fd_sc_mcu9t5v0__aoi21_1_20 tx_state[2] \_136_ \_134_ VDD VSS \_137_
+ gf180mcu_fd_sc_mcu9t5v0__aoi21_1
* cell instance gf180mcu_fd_sc_mcu9t5v0__aoi21_1_21 r0 *1 0,0
Xgf180mcu_fd_sc_mcu9t5v0__aoi21_1_21 byte_idx[0] byte_idx[1] \_140_ VDD VSS
+ \_141_ gf180mcu_fd_sc_mcu9t5v0__aoi21_1
* cell instance gf180mcu_fd_sc_mcu9t5v0__aoi21_2_0 r0 *1 0,0
Xgf180mcu_fd_sc_mcu9t5v0__aoi21_2_0 u_destuffer/_08_ rx_receiving
+ u_destuffer/_09_ VDD VSS u_destuffer/_10_ gf180mcu_fd_sc_mcu9t5v0__aoi21_2
* cell instance gf180mcu_fd_sc_mcu9t5v0__aoi21_2_1 r0 *1 0,0
Xgf180mcu_fd_sc_mcu9t5v0__aoi21_2_1 tx_body_active u_stuffer/_09_
+ u_stuffer/_13_ VDD VSS u_stuffer/_02_ gf180mcu_fd_sc_mcu9t5v0__aoi21_2
* cell instance gf180mcu_fd_sc_mcu9t5v0__aoi21_2_2 r0 *1 0,0
Xgf180mcu_fd_sc_mcu9t5v0__aoi21_2_2 tx_body_active u_stuffer/_09_
+ u_stuffer/_11_ VDD VSS u_stuffer/_01_ gf180mcu_fd_sc_mcu9t5v0__aoi21_2
* cell instance gf180mcu_fd_sc_mcu9t5v0__aoi21_2_3 r0 *1 0,0
Xgf180mcu_fd_sc_mcu9t5v0__aoi21_2_3 u_stuffer/_03_ stuff_consume \_008_ VDD VSS
+ u_stuffer/_06_ gf180mcu_fd_sc_mcu9t5v0__aoi21_2
* cell instance gf180mcu_fd_sc_mcu9t5v0__aoi21_4_0 r0 *1 0,0
Xgf180mcu_fd_sc_mcu9t5v0__aoi21_4_0 u_destuffer/_08_ rx_receiving
+ u_destuffer/_11_ VDD VSS u_destuffer/_12_ gf180mcu_fd_sc_mcu9t5v0__aoi21_4
* cell instance gf180mcu_fd_sc_mcu9t5v0__aoi21_4_1 r0 *1 0,0
Xgf180mcu_fd_sc_mcu9t5v0__aoi21_4_1 rx_receiving u_destuffer/_07_
+ u_destuffer/_08_ VDD VSS u_destuffer/_00_ gf180mcu_fd_sc_mcu9t5v0__aoi21_4
* cell instance gf180mcu_fd_sc_mcu9t5v0__aoi221_1_0 r0 *1 0,0
Xgf180mcu_fd_sc_mcu9t5v0__aoi221_1_0 \_062_ entering_sync \_120_ sync_idx[1]
+ \_052_ VDD VSS \_122_ gf180mcu_fd_sc_mcu9t5v0__aoi221_1
* cell instance gf180mcu_fd_sc_mcu9t5v0__aoi22_4_0 r0 *1 0,0
Xgf180mcu_fd_sc_mcu9t5v0__aoi22_4_0 tx_state[2] \_074_ \_091_ \_061_ VDD VSS
+ \_092_ gf180mcu_fd_sc_mcu9t5v0__aoi22_4
* cell instance gf180mcu_fd_sc_mcu9t5v0__buf_4_0 r0 *1 0,0
Xgf180mcu_fd_sc_mcu9t5v0__buf_4_0 clknet_0_clk VDD VSS clknet_3_2__leaf_clk
+ gf180mcu_fd_sc_mcu9t5v0__buf_4
* cell instance gf180mcu_fd_sc_mcu9t5v0__buf_4_1 r0 *1 0,0
Xgf180mcu_fd_sc_mcu9t5v0__buf_4_1 clknet_0_clk VDD VSS clknet_3_0__leaf_clk
+ gf180mcu_fd_sc_mcu9t5v0__buf_4
* cell instance gf180mcu_fd_sc_mcu9t5v0__buf_4_2 r0 *1 0,0
Xgf180mcu_fd_sc_mcu9t5v0__buf_4_2 clknet_0_clk VDD VSS clknet_3_1__leaf_clk
+ gf180mcu_fd_sc_mcu9t5v0__buf_4
* cell instance gf180mcu_fd_sc_mcu9t5v0__buf_4_3 r0 *1 0,0
Xgf180mcu_fd_sc_mcu9t5v0__buf_4_3 clknet_0_clk VDD VSS clknet_3_3__leaf_clk
+ gf180mcu_fd_sc_mcu9t5v0__buf_4
* cell instance gf180mcu_fd_sc_mcu9t5v0__buf_4_4 r0 *1 0,0
Xgf180mcu_fd_sc_mcu9t5v0__buf_4_4 clk VDD VSS clknet_0_clk
+ gf180mcu_fd_sc_mcu9t5v0__buf_4
* cell instance gf180mcu_fd_sc_mcu9t5v0__buf_4_5 r0 *1 0,0
Xgf180mcu_fd_sc_mcu9t5v0__buf_4_5 clknet_0_clk VDD VSS clknet_3_6__leaf_clk
+ gf180mcu_fd_sc_mcu9t5v0__buf_4
* cell instance gf180mcu_fd_sc_mcu9t5v0__buf_4_6 r0 *1 0,0
Xgf180mcu_fd_sc_mcu9t5v0__buf_4_6 clknet_0_clk VDD VSS clknet_3_4__leaf_clk
+ gf180mcu_fd_sc_mcu9t5v0__buf_4
* cell instance gf180mcu_fd_sc_mcu9t5v0__buf_4_7 r0 *1 0,0
Xgf180mcu_fd_sc_mcu9t5v0__buf_4_7 clknet_0_clk VDD VSS clknet_3_7__leaf_clk
+ gf180mcu_fd_sc_mcu9t5v0__buf_4
* cell instance gf180mcu_fd_sc_mcu9t5v0__buf_4_8 r0 *1 0,0
Xgf180mcu_fd_sc_mcu9t5v0__buf_4_8 clknet_0_clk VDD VSS clknet_3_5__leaf_clk
+ gf180mcu_fd_sc_mcu9t5v0__buf_4
* cell instance gf180mcu_fd_sc_mcu9t5v0__clkinv_1_0 r0 *1 0,0
Xgf180mcu_fd_sc_mcu9t5v0__clkinv_1_0 u_decoder/_04_ VDD VSS u_decoder/_00_
+ gf180mcu_fd_sc_mcu9t5v0__clkinv_1
* cell instance gf180mcu_fd_sc_mcu9t5v0__clkinv_1_1 r0 *1 0,0
Xgf180mcu_fd_sc_mcu9t5v0__clkinv_1_1 \_089_ VDD VSS \_017_
+ gf180mcu_fd_sc_mcu9t5v0__clkinv_1
* cell instance gf180mcu_fd_sc_mcu9t5v0__clkinv_1_2 r0 *1 0,0
Xgf180mcu_fd_sc_mcu9t5v0__clkinv_1_2 u_sync_detector/match[3] VDD VSS
+ u_sync_detector/_08_ gf180mcu_fd_sc_mcu9t5v0__clkinv_1
* cell instance gf180mcu_fd_sc_mcu9t5v0__clkinv_1_3 r0 *1 0,0
Xgf180mcu_fd_sc_mcu9t5v0__clkinv_1_3 u_eop_detector/se0_count[4] VDD VSS
+ u_eop_detector/_22_ gf180mcu_fd_sc_mcu9t5v0__clkinv_1
* cell instance gf180mcu_fd_sc_mcu9t5v0__clkinv_1_4 r0 *1 0,0
Xgf180mcu_fd_sc_mcu9t5v0__clkinv_1_4 \_010_ VDD VSS u_sync_detector/_05_
+ gf180mcu_fd_sc_mcu9t5v0__clkinv_1
* cell instance gf180mcu_fd_sc_mcu9t5v0__clkinv_1_5 r0 *1 0,0
Xgf180mcu_fd_sc_mcu9t5v0__clkinv_1_5 rx_receiving VDD VSS \_010_
+ gf180mcu_fd_sc_mcu9t5v0__clkinv_1
* cell instance gf180mcu_fd_sc_mcu9t5v0__clkinv_1_6 r0 *1 0,0
Xgf180mcu_fd_sc_mcu9t5v0__clkinv_1_6 \_139_ VDD VSS \_046_
+ gf180mcu_fd_sc_mcu9t5v0__clkinv_1
* cell instance gf180mcu_fd_sc_mcu9t5v0__clkinv_1_7 r0 *1 0,0
Xgf180mcu_fd_sc_mcu9t5v0__clkinv_1_7 line_state[0] VDD VSS \_067_
+ gf180mcu_fd_sc_mcu9t5v0__clkinv_1
* cell instance gf180mcu_fd_sc_mcu9t5v0__clkinv_1_8 r0 *1 0,0
Xgf180mcu_fd_sc_mcu9t5v0__clkinv_1_8 DataOut[4] VDD VSS \_099_
+ gf180mcu_fd_sc_mcu9t5v0__clkinv_1
* cell instance gf180mcu_fd_sc_mcu9t5v0__clkinv_1_9 r0 *1 0,0
Xgf180mcu_fd_sc_mcu9t5v0__clkinv_1_9 DataOut[1] VDD VSS \_107_
+ gf180mcu_fd_sc_mcu9t5v0__clkinv_1
* cell instance gf180mcu_fd_sc_mcu9t5v0__clkinv_1_10 r0 *1 0,0
Xgf180mcu_fd_sc_mcu9t5v0__clkinv_1_10 DataOut[3] VDD VSS \_101_
+ gf180mcu_fd_sc_mcu9t5v0__clkinv_1
* cell instance gf180mcu_fd_sc_mcu9t5v0__clkinv_1_11 r0 *1 0,0
Xgf180mcu_fd_sc_mcu9t5v0__clkinv_1_11 u_eop_detector/se0_count[0] VDD VSS
+ u_eop_detector/_11_ gf180mcu_fd_sc_mcu9t5v0__clkinv_1
* cell instance gf180mcu_fd_sc_mcu9t5v0__clkinv_1_12 r0 *1 0,0
Xgf180mcu_fd_sc_mcu9t5v0__clkinv_1_12 u_eop_detector/se0_count[5] VDD VSS
+ u_eop_detector/_17_ gf180mcu_fd_sc_mcu9t5v0__clkinv_1
* cell instance gf180mcu_fd_sc_mcu9t5v0__clkinv_1_13 r0 *1 0,0
Xgf180mcu_fd_sc_mcu9t5v0__clkinv_1_13 Reset VDD VSS \_051_
+ gf180mcu_fd_sc_mcu9t5v0__clkinv_1
* cell instance gf180mcu_fd_sc_mcu9t5v0__clkinv_1_14 r0 *1 0,0
Xgf180mcu_fd_sc_mcu9t5v0__clkinv_1_14 OpMode[1] VDD VSS \_077_
+ gf180mcu_fd_sc_mcu9t5v0__clkinv_1
* cell instance gf180mcu_fd_sc_mcu9t5v0__clkinv_1_15 r0 *1 0,0
Xgf180mcu_fd_sc_mcu9t5v0__clkinv_1_15 DataOut[5] VDD VSS \_097_
+ gf180mcu_fd_sc_mcu9t5v0__clkinv_1
* cell instance gf180mcu_fd_sc_mcu9t5v0__clkinv_1_16 r0 *1 0,0
Xgf180mcu_fd_sc_mcu9t5v0__clkinv_1_16 \_068_ VDD VSS tx_body_active
+ gf180mcu_fd_sc_mcu9t5v0__clkinv_1
* cell instance gf180mcu_fd_sc_mcu9t5v0__clkinv_1_17 r0 *1 0,0
Xgf180mcu_fd_sc_mcu9t5v0__clkinv_1_17 tx_state[7] VDD VSS \_060_
+ gf180mcu_fd_sc_mcu9t5v0__clkinv_1
* cell instance gf180mcu_fd_sc_mcu9t5v0__clkinv_1_18 r0 *1 0,0
Xgf180mcu_fd_sc_mcu9t5v0__clkinv_1_18 DataOut[0] VDD VSS \_109_
+ gf180mcu_fd_sc_mcu9t5v0__clkinv_1
* cell instance gf180mcu_fd_sc_mcu9t5v0__clkinv_1_19 r0 *1 0,0
Xgf180mcu_fd_sc_mcu9t5v0__clkinv_1_19 stuff_consume VDD VSS \_072_
+ gf180mcu_fd_sc_mcu9t5v0__clkinv_1
* cell instance gf180mcu_fd_sc_mcu9t5v0__clkinv_1_20 r0 *1 0,0
Xgf180mcu_fd_sc_mcu9t5v0__clkinv_1_20 stuff_pending_after VDD VSS \_066_
+ gf180mcu_fd_sc_mcu9t5v0__clkinv_1
* cell instance gf180mcu_fd_sc_mcu9t5v0__clkinv_1_21 r0 *1 0,0
Xgf180mcu_fd_sc_mcu9t5v0__clkinv_1_21 tx_state[0] VDD VSS \_059_
+ gf180mcu_fd_sc_mcu9t5v0__clkinv_1
* cell instance gf180mcu_fd_sc_mcu9t5v0__clkinv_1_22 r0 *1 0,0
Xgf180mcu_fd_sc_mcu9t5v0__clkinv_1_22 raw_mode VDD VSS u_stuffer/_07_
+ gf180mcu_fd_sc_mcu9t5v0__clkinv_1
* cell instance gf180mcu_fd_sc_mcu9t5v0__clkinv_1_23 r0 *1 0,0
Xgf180mcu_fd_sc_mcu9t5v0__clkinv_1_23 DataOut[6] VDD VSS \_090_
+ gf180mcu_fd_sc_mcu9t5v0__clkinv_1
* cell instance gf180mcu_fd_sc_mcu9t5v0__clkinv_1_24 r0 *1 0,0
Xgf180mcu_fd_sc_mcu9t5v0__clkinv_1_24 DataOut[7] VDD VSS \_129_
+ gf180mcu_fd_sc_mcu9t5v0__clkinv_1
* cell instance gf180mcu_fd_sc_mcu9t5v0__clkinv_1_25 r0 *1 0,0
Xgf180mcu_fd_sc_mcu9t5v0__clkinv_1_25 first_byte VDD VSS \_124_
+ gf180mcu_fd_sc_mcu9t5v0__clkinv_1
* cell instance gf180mcu_fd_sc_mcu9t5v0__clkinv_1_26 r0 *1 0,0
Xgf180mcu_fd_sc_mcu9t5v0__clkinv_1_26 \_061_ VDD VSS entering_sync
+ gf180mcu_fd_sc_mcu9t5v0__clkinv_1
* cell instance gf180mcu_fd_sc_mcu9t5v0__clkinv_1_27 r0 *1 0,0
Xgf180mcu_fd_sc_mcu9t5v0__clkinv_1_27 tx_state[4] VDD VSS \_062_
+ gf180mcu_fd_sc_mcu9t5v0__clkinv_1
* cell instance gf180mcu_fd_sc_mcu9t5v0__clkinv_1_28 r0 *1 0,0
Xgf180mcu_fd_sc_mcu9t5v0__clkinv_1_28 byte_idx[1] VDD VSS \_080_
+ gf180mcu_fd_sc_mcu9t5v0__clkinv_1
* cell instance gf180mcu_fd_sc_mcu9t5v0__clkinv_1_29 r0 *1 0,0
Xgf180mcu_fd_sc_mcu9t5v0__clkinv_1_29 DataOut[2] VDD VSS \_105_
+ gf180mcu_fd_sc_mcu9t5v0__clkinv_1
* cell instance gf180mcu_fd_sc_mcu9t5v0__clkinv_1_30 r0 *1 0,0
Xgf180mcu_fd_sc_mcu9t5v0__clkinv_1_30 byte_idx[0] VDD VSS \_132_
+ gf180mcu_fd_sc_mcu9t5v0__clkinv_1
* cell instance gf180mcu_fd_sc_mcu9t5v0__clkinv_1_31 r0 *1 0,0
Xgf180mcu_fd_sc_mcu9t5v0__clkinv_1_31 byte_idx[2] VDD VSS \_131_
+ gf180mcu_fd_sc_mcu9t5v0__clkinv_1
* cell instance gf180mcu_fd_sc_mcu9t5v0__clkinv_8_0 r0 *1 0,0
Xgf180mcu_fd_sc_mcu9t5v0__clkinv_8_0 clknet_3_5__leaf_clk VDD VSS \$227
+ gf180mcu_fd_sc_mcu9t5v0__clkinv_8
* cell instance gf180mcu_fd_sc_mcu9t5v0__dffq_1_0 r0 *1 0,0
Xgf180mcu_fd_sc_mcu9t5v0__dffq_1_0 clknet_3_2__leaf_clk \_033_ rx_bitcnt[0] VDD
+ VSS gf180mcu_fd_sc_mcu9t5v0__dffq_1
* cell instance gf180mcu_fd_sc_mcu9t5v0__dffq_1_1 r0 *1 0,0
Xgf180mcu_fd_sc_mcu9t5v0__dffq_1_1 clknet_3_2__leaf_clk \_028_ rx_shift[1] VDD
+ VSS gf180mcu_fd_sc_mcu9t5v0__dffq_1
* cell instance gf180mcu_fd_sc_mcu9t5v0__dffq_1_2 r0 *1 0,0
Xgf180mcu_fd_sc_mcu9t5v0__dffq_1_2 clknet_3_2__leaf_clk \_044_ DataIn[0] VDD
+ VSS gf180mcu_fd_sc_mcu9t5v0__dffq_1
* cell instance gf180mcu_fd_sc_mcu9t5v0__dffq_1_3 r0 *1 0,0
Xgf180mcu_fd_sc_mcu9t5v0__dffq_1_3 clknet_3_2__leaf_clk \_049_ rx_bitcnt[1] VDD
+ VSS gf180mcu_fd_sc_mcu9t5v0__dffq_1
* cell instance gf180mcu_fd_sc_mcu9t5v0__dffq_1_4 r0 *1 0,0
Xgf180mcu_fd_sc_mcu9t5v0__dffq_1_4 clknet_3_2__leaf_clk \_027_ rx_shift[2] VDD
+ VSS gf180mcu_fd_sc_mcu9t5v0__dffq_1
* cell instance gf180mcu_fd_sc_mcu9t5v0__dffq_1_5 r0 *1 0,0
Xgf180mcu_fd_sc_mcu9t5v0__dffq_1_5 clknet_3_0__leaf_clk u_sync_detector/_02_
+ u_sync_detector/match[1] VDD VSS gf180mcu_fd_sc_mcu9t5v0__dffq_1
* cell instance gf180mcu_fd_sc_mcu9t5v0__dffq_1_6 r0 *1 0,0
Xgf180mcu_fd_sc_mcu9t5v0__dffq_1_6 clknet_3_2__leaf_clk \_043_ DataIn[1] VDD
+ VSS gf180mcu_fd_sc_mcu9t5v0__dffq_1
* cell instance gf180mcu_fd_sc_mcu9t5v0__dffq_1_7 r0 *1 0,0
Xgf180mcu_fd_sc_mcu9t5v0__dffq_1_7 clknet_3_2__leaf_clk \_026_ rx_shift[3] VDD
+ VSS gf180mcu_fd_sc_mcu9t5v0__dffq_1
* cell instance gf180mcu_fd_sc_mcu9t5v0__dffq_1_8 r0 *1 0,0
Xgf180mcu_fd_sc_mcu9t5v0__dffq_1_8 clknet_3_0__leaf_clk u_sync_detector/_01_
+ u_sync_detector/match[2] VDD VSS gf180mcu_fd_sc_mcu9t5v0__dffq_1
* cell instance gf180mcu_fd_sc_mcu9t5v0__dffq_1_9 r0 *1 0,0
Xgf180mcu_fd_sc_mcu9t5v0__dffq_1_9 clknet_3_0__leaf_clk u_sync_detector/_03_
+ u_sync_detector/match[0] VDD VSS gf180mcu_fd_sc_mcu9t5v0__dffq_1
* cell instance gf180mcu_fd_sc_mcu9t5v0__dffq_1_10 r0 *1 0,0
Xgf180mcu_fd_sc_mcu9t5v0__dffq_1_10 clknet_3_2__leaf_clk \_036_ rx_bitcnt[2]
+ VDD VSS gf180mcu_fd_sc_mcu9t5v0__dffq_1
* cell instance gf180mcu_fd_sc_mcu9t5v0__dffq_1_11 r0 *1 0,0
Xgf180mcu_fd_sc_mcu9t5v0__dffq_1_11 clknet_3_2__leaf_clk \_042_ DataIn[2] VDD
+ VSS gf180mcu_fd_sc_mcu9t5v0__dffq_1
* cell instance gf180mcu_fd_sc_mcu9t5v0__dffq_1_12 r0 *1 0,0
Xgf180mcu_fd_sc_mcu9t5v0__dffq_1_12 clknet_3_2__leaf_clk \_025_ rx_shift[4] VDD
+ VSS gf180mcu_fd_sc_mcu9t5v0__dffq_1
* cell instance gf180mcu_fd_sc_mcu9t5v0__dffq_1_13 r0 *1 0,0
Xgf180mcu_fd_sc_mcu9t5v0__dffq_1_13 clknet_3_0__leaf_clk u_eop_detector/_01_
+ u_eop_detector/se0_count[2] VDD VSS gf180mcu_fd_sc_mcu9t5v0__dffq_1
* cell instance gf180mcu_fd_sc_mcu9t5v0__dffq_1_14 r0 *1 0,0
Xgf180mcu_fd_sc_mcu9t5v0__dffq_1_14 clknet_3_1__leaf_clk u_sync_detector/_00_
+ u_sync_detector/match[3] VDD VSS gf180mcu_fd_sc_mcu9t5v0__dffq_1
* cell instance gf180mcu_fd_sc_mcu9t5v0__dffq_1_15 r0 *1 0,0
Xgf180mcu_fd_sc_mcu9t5v0__dffq_1_15 clknet_3_2__leaf_clk \_039_ DataIn[3] VDD
+ VSS gf180mcu_fd_sc_mcu9t5v0__dffq_1
* cell instance gf180mcu_fd_sc_mcu9t5v0__dffq_1_16 r0 *1 0,0
Xgf180mcu_fd_sc_mcu9t5v0__dffq_1_16 clknet_3_2__leaf_clk \_017_ rx_assembly_en
+ VDD VSS gf180mcu_fd_sc_mcu9t5v0__dffq_1
* cell instance gf180mcu_fd_sc_mcu9t5v0__dffq_1_17 r0 *1 0,0
Xgf180mcu_fd_sc_mcu9t5v0__dffq_1_17 clknet_3_1__leaf_clk u_eop_detector/_04_
+ u_eop_detector/se0_count[4] VDD VSS gf180mcu_fd_sc_mcu9t5v0__dffq_1
* cell instance gf180mcu_fd_sc_mcu9t5v0__dffq_1_18 r0 *1 0,0
Xgf180mcu_fd_sc_mcu9t5v0__dffq_1_18 clknet_3_3__leaf_clk \_021_ rx_shift[7] VDD
+ VSS gf180mcu_fd_sc_mcu9t5v0__dffq_1
* cell instance gf180mcu_fd_sc_mcu9t5v0__dffq_1_19 r0 *1 0,0
Xgf180mcu_fd_sc_mcu9t5v0__dffq_1_19 clknet_3_3__leaf_clk \_014_ rx_shift[5] VDD
+ VSS gf180mcu_fd_sc_mcu9t5v0__dffq_1
* cell instance gf180mcu_fd_sc_mcu9t5v0__dffq_1_20 r0 *1 0,0
Xgf180mcu_fd_sc_mcu9t5v0__dffq_1_20 clknet_3_3__leaf_clk \_050_ rx_shift[6] VDD
+ VSS gf180mcu_fd_sc_mcu9t5v0__dffq_1
* cell instance gf180mcu_fd_sc_mcu9t5v0__dffq_1_21 r0 *1 0,0
Xgf180mcu_fd_sc_mcu9t5v0__dffq_1_21 clknet_3_1__leaf_clk u_eop_detector/_05_
+ u_eop_detector/se0_count[3] VDD VSS gf180mcu_fd_sc_mcu9t5v0__dffq_1
* cell instance gf180mcu_fd_sc_mcu9t5v0__dffq_1_22 r0 *1 0,0
Xgf180mcu_fd_sc_mcu9t5v0__dffq_1_22 clknet_3_1__leaf_clk u_eop_detector/_07_
+ eop_pulse VDD VSS gf180mcu_fd_sc_mcu9t5v0__dffq_1
* cell instance gf180mcu_fd_sc_mcu9t5v0__dffq_1_23 r0 *1 0,0
Xgf180mcu_fd_sc_mcu9t5v0__dffq_1_23 clknet_3_3__leaf_clk \_037_ DataIn[4] VDD
+ VSS gf180mcu_fd_sc_mcu9t5v0__dffq_1
* cell instance gf180mcu_fd_sc_mcu9t5v0__dffq_1_24 r0 *1 0,0
Xgf180mcu_fd_sc_mcu9t5v0__dffq_1_24 clknet_3_1__leaf_clk \_046_ rx_receiving
+ VDD VSS gf180mcu_fd_sc_mcu9t5v0__dffq_1
* cell instance gf180mcu_fd_sc_mcu9t5v0__dffq_1_25 r0 *1 0,0
Xgf180mcu_fd_sc_mcu9t5v0__dffq_1_25 clknet_3_3__leaf_clk \_045_ RxError VDD VSS
+ gf180mcu_fd_sc_mcu9t5v0__dffq_1
* cell instance gf180mcu_fd_sc_mcu9t5v0__dffq_1_26 r0 *1 0,0
Xgf180mcu_fd_sc_mcu9t5v0__dffq_1_26 clknet_3_3__leaf_clk \_034_ DataIn[6] VDD
+ VSS gf180mcu_fd_sc_mcu9t5v0__dffq_1
* cell instance gf180mcu_fd_sc_mcu9t5v0__dffq_1_27 r0 *1 0,0
Xgf180mcu_fd_sc_mcu9t5v0__dffq_1_27 clknet_3_3__leaf_clk \_001_ tx_state[5] VDD
+ VSS gf180mcu_fd_sc_mcu9t5v0__dffq_1
* cell instance gf180mcu_fd_sc_mcu9t5v0__dffq_1_28 r0 *1 0,0
Xgf180mcu_fd_sc_mcu9t5v0__dffq_1_28 clknet_3_3__leaf_clk \_035_ DataIn[5] VDD
+ VSS gf180mcu_fd_sc_mcu9t5v0__dffq_1
* cell instance gf180mcu_fd_sc_mcu9t5v0__dffq_1_29 r0 *1 0,0
Xgf180mcu_fd_sc_mcu9t5v0__dffq_1_29 clknet_3_1__leaf_clk u_eop_detector/_00_
+ bus_reset VDD VSS gf180mcu_fd_sc_mcu9t5v0__dffq_1
* cell instance gf180mcu_fd_sc_mcu9t5v0__dffq_1_30 r0 *1 0,0
Xgf180mcu_fd_sc_mcu9t5v0__dffq_1_30 clknet_3_3__leaf_clk \_000_ tx_state[3] VDD
+ VSS gf180mcu_fd_sc_mcu9t5v0__dffq_1
* cell instance gf180mcu_fd_sc_mcu9t5v0__dffq_1_31 r0 *1 0,0
Xgf180mcu_fd_sc_mcu9t5v0__dffq_1_31 clknet_3_3__leaf_clk \_016_ DataIn[7] VDD
+ VSS gf180mcu_fd_sc_mcu9t5v0__dffq_1
* cell instance gf180mcu_fd_sc_mcu9t5v0__dffq_1_32 r0 *1 0,0
Xgf180mcu_fd_sc_mcu9t5v0__dffq_1_32 clknet_3_1__leaf_clk u_eop_detector/_02_
+ u_eop_detector/se0_count[1] VDD VSS gf180mcu_fd_sc_mcu9t5v0__dffq_1
* cell instance gf180mcu_fd_sc_mcu9t5v0__dffq_1_33 r0 *1 0,0
Xgf180mcu_fd_sc_mcu9t5v0__dffq_1_33 clknet_3_3__leaf_clk \_096_ RxValid VDD VSS
+ gf180mcu_fd_sc_mcu9t5v0__dffq_1
* cell instance gf180mcu_fd_sc_mcu9t5v0__dffq_1_34 r0 *1 0,0
Xgf180mcu_fd_sc_mcu9t5v0__dffq_1_34 clknet_3_1__leaf_clk u_sync_detector/_04_
+ u_sync_detector/sync_valid VDD VSS gf180mcu_fd_sc_mcu9t5v0__dffq_1
* cell instance gf180mcu_fd_sc_mcu9t5v0__dffq_1_35 r0 *1 0,0
Xgf180mcu_fd_sc_mcu9t5v0__dffq_1_35 clknet_3_6__leaf_clk u_line_state/_0_
+ line_state[0] VDD VSS gf180mcu_fd_sc_mcu9t5v0__dffq_1
* cell instance gf180mcu_fd_sc_mcu9t5v0__dffq_1_36 r0 *1 0,0
Xgf180mcu_fd_sc_mcu9t5v0__dffq_1_36 clknet_3_4__leaf_clk u_eop_detector/_06_
+ u_eop_detector/se0_count[5] VDD VSS gf180mcu_fd_sc_mcu9t5v0__dffq_1
* cell instance gf180mcu_fd_sc_mcu9t5v0__dffq_1_37 r0 *1 0,0
Xgf180mcu_fd_sc_mcu9t5v0__dffq_1_37 clknet_3_6__leaf_clk \_003_ tx_state[7] VDD
+ VSS gf180mcu_fd_sc_mcu9t5v0__dffq_1
* cell instance gf180mcu_fd_sc_mcu9t5v0__dffq_1_38 r0 *1 0,0
Xgf180mcu_fd_sc_mcu9t5v0__dffq_1_38 clknet_3_6__leaf_clk u_line_state/_1_
+ line_state[1] VDD VSS gf180mcu_fd_sc_mcu9t5v0__dffq_1
* cell instance gf180mcu_fd_sc_mcu9t5v0__dffq_1_39 r0 *1 0,0
Xgf180mcu_fd_sc_mcu9t5v0__dffq_1_39 clknet_3_6__leaf_clk \_005_ tx_state[1] VDD
+ VSS gf180mcu_fd_sc_mcu9t5v0__dffq_1
* cell instance gf180mcu_fd_sc_mcu9t5v0__dffq_1_40 r0 *1 0,0
Xgf180mcu_fd_sc_mcu9t5v0__dffq_1_40 clknet_3_4__leaf_clk u_eop_detector/_03_
+ u_eop_detector/se0_count[0] VDD VSS gf180mcu_fd_sc_mcu9t5v0__dffq_1
* cell instance gf180mcu_fd_sc_mcu9t5v0__dffq_1_41 r0 *1 0,0
Xgf180mcu_fd_sc_mcu9t5v0__dffq_1_41 clknet_3_6__leaf_clk \_019_ byte_reg[4] VDD
+ VSS gf180mcu_fd_sc_mcu9t5v0__dffq_1
* cell instance gf180mcu_fd_sc_mcu9t5v0__dffq_1_42 r0 *1 0,0
Xgf180mcu_fd_sc_mcu9t5v0__dffq_1_42 clknet_3_6__leaf_clk \_018_ byte_reg[5] VDD
+ VSS gf180mcu_fd_sc_mcu9t5v0__dffq_1
* cell instance gf180mcu_fd_sc_mcu9t5v0__dffq_1_43 r0 *1 0,0
Xgf180mcu_fd_sc_mcu9t5v0__dffq_1_43 clknet_3_6__leaf_clk \_004_ tx_state[0] VDD
+ VSS gf180mcu_fd_sc_mcu9t5v0__dffq_1
* cell instance gf180mcu_fd_sc_mcu9t5v0__dffq_1_44 r0 *1 0,0
Xgf180mcu_fd_sc_mcu9t5v0__dffq_1_44 clknet_3_6__leaf_clk \_023_ byte_reg[1] VDD
+ VSS gf180mcu_fd_sc_mcu9t5v0__dffq_1
* cell instance gf180mcu_fd_sc_mcu9t5v0__dffq_1_45 r0 *1 0,0
Xgf180mcu_fd_sc_mcu9t5v0__dffq_1_45 clknet_3_7__leaf_clk \_024_ byte_reg[0] VDD
+ VSS gf180mcu_fd_sc_mcu9t5v0__dffq_1
* cell instance gf180mcu_fd_sc_mcu9t5v0__dffq_1_46 r0 *1 0,0
Xgf180mcu_fd_sc_mcu9t5v0__dffq_1_46 clknet_3_5__leaf_clk \_002_ tx_state[6] VDD
+ VSS gf180mcu_fd_sc_mcu9t5v0__dffq_1
* cell instance gf180mcu_fd_sc_mcu9t5v0__dffq_1_47 r0 *1 0,0
Xgf180mcu_fd_sc_mcu9t5v0__dffq_1_47 clknet_3_7__leaf_clk \_015_ byte_reg[6] VDD
+ VSS gf180mcu_fd_sc_mcu9t5v0__dffq_1
* cell instance gf180mcu_fd_sc_mcu9t5v0__dffq_1_48 r0 *1 0,0
Xgf180mcu_fd_sc_mcu9t5v0__dffq_1_48 clknet_3_7__leaf_clk \_031_ first_byte VDD
+ VSS gf180mcu_fd_sc_mcu9t5v0__dffq_1
* cell instance gf180mcu_fd_sc_mcu9t5v0__dffq_1_49 r0 *1 0,0
Xgf180mcu_fd_sc_mcu9t5v0__dffq_1_49 clknet_3_5__leaf_clk \_007_ tx_state[4] VDD
+ VSS gf180mcu_fd_sc_mcu9t5v0__dffq_1
* cell instance gf180mcu_fd_sc_mcu9t5v0__dffq_1_50 r0 *1 0,0
Xgf180mcu_fd_sc_mcu9t5v0__dffq_1_50 clknet_3_7__leaf_clk \_038_ byte_reg[7] VDD
+ VSS gf180mcu_fd_sc_mcu9t5v0__dffq_1
* cell instance gf180mcu_fd_sc_mcu9t5v0__dffq_1_51 r0 *1 0,0
Xgf180mcu_fd_sc_mcu9t5v0__dffq_1_51 clknet_3_5__leaf_clk \_029_ sync_idx[1] VDD
+ VSS gf180mcu_fd_sc_mcu9t5v0__dffq_1
* cell instance gf180mcu_fd_sc_mcu9t5v0__dffq_1_52 r0 *1 0,0
Xgf180mcu_fd_sc_mcu9t5v0__dffq_1_52 clknet_3_7__leaf_clk \_020_ byte_reg[3] VDD
+ VSS gf180mcu_fd_sc_mcu9t5v0__dffq_1
* cell instance gf180mcu_fd_sc_mcu9t5v0__dffq_1_53 r0 *1 0,0
Xgf180mcu_fd_sc_mcu9t5v0__dffq_1_53 clknet_3_5__leaf_clk \_030_ sync_idx[2] VDD
+ VSS gf180mcu_fd_sc_mcu9t5v0__dffq_1
* cell instance gf180mcu_fd_sc_mcu9t5v0__dffq_1_54 r0 *1 0,0
Xgf180mcu_fd_sc_mcu9t5v0__dffq_1_54 clknet_3_7__leaf_clk \_047_ byte_idx[1] VDD
+ VSS gf180mcu_fd_sc_mcu9t5v0__dffq_1
* cell instance gf180mcu_fd_sc_mcu9t5v0__dffq_1_55 r0 *1 0,0
Xgf180mcu_fd_sc_mcu9t5v0__dffq_1_55 clknet_3_5__leaf_clk \_032_ sync_idx[0] VDD
+ VSS gf180mcu_fd_sc_mcu9t5v0__dffq_1
* cell instance gf180mcu_fd_sc_mcu9t5v0__dffq_1_56 r0 *1 0,0
Xgf180mcu_fd_sc_mcu9t5v0__dffq_1_56 clknet_3_5__leaf_clk \_006_ tx_state[2] VDD
+ VSS gf180mcu_fd_sc_mcu9t5v0__dffq_1
* cell instance gf180mcu_fd_sc_mcu9t5v0__dffq_1_57 r0 *1 0,0
Xgf180mcu_fd_sc_mcu9t5v0__dffq_1_57 clknet_3_7__leaf_clk \_048_ byte_idx[0] VDD
+ VSS gf180mcu_fd_sc_mcu9t5v0__dffq_1
* cell instance gf180mcu_fd_sc_mcu9t5v0__dffq_1_58 r0 *1 0,0
Xgf180mcu_fd_sc_mcu9t5v0__dffq_1_58 clknet_3_7__leaf_clk \_040_ byte_idx[2] VDD
+ VSS gf180mcu_fd_sc_mcu9t5v0__dffq_1
* cell instance gf180mcu_fd_sc_mcu9t5v0__dffq_1_59 r0 *1 0,0
Xgf180mcu_fd_sc_mcu9t5v0__dffq_1_59 clknet_3_7__leaf_clk \_022_ byte_reg[2] VDD
+ VSS gf180mcu_fd_sc_mcu9t5v0__dffq_1
* cell instance gf180mcu_fd_sc_mcu9t5v0__dffrnq_1_0 r0 *1 0,0
Xgf180mcu_fd_sc_mcu9t5v0__dffrnq_1_0 clknet_3_2__leaf_clk u_destuffer/_02_
+ u_destuffer/ones_run[1] \_053_ VDD VSS gf180mcu_fd_sc_mcu9t5v0__dffrnq_1
* cell instance gf180mcu_fd_sc_mcu9t5v0__dffrnq_1_1 r0 *1 0,0
Xgf180mcu_fd_sc_mcu9t5v0__dffrnq_1_1 clknet_3_2__leaf_clk u_destuffer/_04_
+ u_destuffer/ones_run[2] \_053_ VDD VSS gf180mcu_fd_sc_mcu9t5v0__dffrnq_1
* cell instance gf180mcu_fd_sc_mcu9t5v0__dffrnq_1_2 r0 *1 0,0
Xgf180mcu_fd_sc_mcu9t5v0__dffrnq_1_2 clknet_3_0__leaf_clk u_destuffer/_05_
+ u_destuffer/ones_run[0] \_053_ VDD VSS gf180mcu_fd_sc_mcu9t5v0__dffrnq_1
* cell instance gf180mcu_fd_sc_mcu9t5v0__dffrnq_1_3 r0 *1 0,0
Xgf180mcu_fd_sc_mcu9t5v0__dffrnq_1_3 clknet_3_2__leaf_clk u_destuffer/_00_
+ rx_bit_valid \_053_ VDD VSS gf180mcu_fd_sc_mcu9t5v0__dffrnq_1
* cell instance gf180mcu_fd_sc_mcu9t5v0__dffrnq_1_4 r0 *1 0,0
Xgf180mcu_fd_sc_mcu9t5v0__dffrnq_1_4 clknet_3_0__leaf_clk u_decoder/_00_
+ dec_data_strobe \_053_ VDD VSS gf180mcu_fd_sc_mcu9t5v0__dffrnq_1
* cell instance gf180mcu_fd_sc_mcu9t5v0__dffrnq_1_5 r0 *1 0,0
Xgf180mcu_fd_sc_mcu9t5v0__dffrnq_1_5 clknet_3_0__leaf_clk u_decoder/_02_
+ dec_data_bit \_053_ VDD VSS gf180mcu_fd_sc_mcu9t5v0__dffrnq_1
* cell instance gf180mcu_fd_sc_mcu9t5v0__dffrnq_1_6 r0 *1 0,0
Xgf180mcu_fd_sc_mcu9t5v0__dffrnq_1_6 clknet_3_0__leaf_clk u_destuffer/_01_
+ rx_stuff_err \_053_ VDD VSS gf180mcu_fd_sc_mcu9t5v0__dffrnq_1
* cell instance gf180mcu_fd_sc_mcu9t5v0__dffrnq_1_7 r0 *1 0,0
Xgf180mcu_fd_sc_mcu9t5v0__dffrnq_1_7 clknet_3_0__leaf_clk u_destuffer/_03_
+ rx_out_bit \_053_ VDD VSS gf180mcu_fd_sc_mcu9t5v0__dffrnq_1
* cell instance gf180mcu_fd_sc_mcu9t5v0__dffrnq_1_8 r0 *1 0,0
Xgf180mcu_fd_sc_mcu9t5v0__dffrnq_1_8 clknet_3_4__leaf_clk u_stuffer/_02_
+ u_stuffer/run[2] \_053_ VDD VSS gf180mcu_fd_sc_mcu9t5v0__dffrnq_1
* cell instance gf180mcu_fd_sc_mcu9t5v0__dffrnq_1_9 r0 *1 0,0
Xgf180mcu_fd_sc_mcu9t5v0__dffrnq_1_9 clknet_3_4__leaf_clk u_stuffer/_01_
+ u_stuffer/run[1] \_053_ VDD VSS gf180mcu_fd_sc_mcu9t5v0__dffrnq_1
* cell instance gf180mcu_fd_sc_mcu9t5v0__dffrnq_1_10 r0 *1 0,0
Xgf180mcu_fd_sc_mcu9t5v0__dffrnq_1_10 clknet_3_5__leaf_clk u_stuffer/_00_
+ u_stuffer/run[0] \_053_ VDD VSS gf180mcu_fd_sc_mcu9t5v0__dffrnq_1
* cell instance gf180mcu_fd_sc_mcu9t5v0__dffsnq_1_0 r0 *1 0,0
Xgf180mcu_fd_sc_mcu9t5v0__dffsnq_1_0 clknet_3_1__leaf_clk u_decoder/_01_
+ u_decoder/prev_level \_053_ VDD VSS gf180mcu_fd_sc_mcu9t5v0__dffsnq_1
* cell instance gf180mcu_fd_sc_mcu9t5v0__dffsnq_1_1 r0 *1 0,0
Xgf180mcu_fd_sc_mcu9t5v0__dffsnq_1_1 clknet_3_4__leaf_clk u_encoder/_0_
+ nrzi_level \_053_ VDD VSS gf180mcu_fd_sc_mcu9t5v0__dffsnq_1
* cell instance gf180mcu_fd_sc_mcu9t5v0__endcap_0 r0 *1 0,0
Xgf180mcu_fd_sc_mcu9t5v0__endcap_0 VDD VSS gf180mcu_fd_sc_mcu9t5v0__endcap
* cell instance gf180mcu_fd_sc_mcu9t5v0__endcap_1 r0 *1 0,0
Xgf180mcu_fd_sc_mcu9t5v0__endcap_1 VDD VSS gf180mcu_fd_sc_mcu9t5v0__endcap
* cell instance gf180mcu_fd_sc_mcu9t5v0__endcap_2 r0 *1 0,0
Xgf180mcu_fd_sc_mcu9t5v0__endcap_2 VDD VSS gf180mcu_fd_sc_mcu9t5v0__endcap
* cell instance gf180mcu_fd_sc_mcu9t5v0__endcap_3 r0 *1 0,0
Xgf180mcu_fd_sc_mcu9t5v0__endcap_3 VDD VSS gf180mcu_fd_sc_mcu9t5v0__endcap
* cell instance gf180mcu_fd_sc_mcu9t5v0__endcap_4 r0 *1 0,0
Xgf180mcu_fd_sc_mcu9t5v0__endcap_4 VDD VSS gf180mcu_fd_sc_mcu9t5v0__endcap
* cell instance gf180mcu_fd_sc_mcu9t5v0__endcap_5 r0 *1 0,0
Xgf180mcu_fd_sc_mcu9t5v0__endcap_5 VDD VSS gf180mcu_fd_sc_mcu9t5v0__endcap
* cell instance gf180mcu_fd_sc_mcu9t5v0__endcap_6 r0 *1 0,0
Xgf180mcu_fd_sc_mcu9t5v0__endcap_6 VDD VSS gf180mcu_fd_sc_mcu9t5v0__endcap
* cell instance gf180mcu_fd_sc_mcu9t5v0__endcap_7 r0 *1 0,0
Xgf180mcu_fd_sc_mcu9t5v0__endcap_7 VDD VSS gf180mcu_fd_sc_mcu9t5v0__endcap
* cell instance gf180mcu_fd_sc_mcu9t5v0__endcap_8 r0 *1 0,0
Xgf180mcu_fd_sc_mcu9t5v0__endcap_8 VDD VSS gf180mcu_fd_sc_mcu9t5v0__endcap
* cell instance gf180mcu_fd_sc_mcu9t5v0__endcap_9 r0 *1 0,0
Xgf180mcu_fd_sc_mcu9t5v0__endcap_9 VDD VSS gf180mcu_fd_sc_mcu9t5v0__endcap
* cell instance gf180mcu_fd_sc_mcu9t5v0__endcap_10 r0 *1 0,0
Xgf180mcu_fd_sc_mcu9t5v0__endcap_10 VDD VSS gf180mcu_fd_sc_mcu9t5v0__endcap
* cell instance gf180mcu_fd_sc_mcu9t5v0__endcap_11 r0 *1 0,0
Xgf180mcu_fd_sc_mcu9t5v0__endcap_11 VDD VSS gf180mcu_fd_sc_mcu9t5v0__endcap
* cell instance gf180mcu_fd_sc_mcu9t5v0__endcap_12 r0 *1 0,0
Xgf180mcu_fd_sc_mcu9t5v0__endcap_12 VDD VSS gf180mcu_fd_sc_mcu9t5v0__endcap
* cell instance gf180mcu_fd_sc_mcu9t5v0__endcap_13 r0 *1 0,0
Xgf180mcu_fd_sc_mcu9t5v0__endcap_13 VDD VSS gf180mcu_fd_sc_mcu9t5v0__endcap
* cell instance gf180mcu_fd_sc_mcu9t5v0__endcap_14 r0 *1 0,0
Xgf180mcu_fd_sc_mcu9t5v0__endcap_14 VDD VSS gf180mcu_fd_sc_mcu9t5v0__endcap
* cell instance gf180mcu_fd_sc_mcu9t5v0__endcap_15 r0 *1 0,0
Xgf180mcu_fd_sc_mcu9t5v0__endcap_15 VDD VSS gf180mcu_fd_sc_mcu9t5v0__endcap
* cell instance gf180mcu_fd_sc_mcu9t5v0__endcap_16 r0 *1 0,0
Xgf180mcu_fd_sc_mcu9t5v0__endcap_16 VDD VSS gf180mcu_fd_sc_mcu9t5v0__endcap
* cell instance gf180mcu_fd_sc_mcu9t5v0__endcap_17 r0 *1 0,0
Xgf180mcu_fd_sc_mcu9t5v0__endcap_17 VDD VSS gf180mcu_fd_sc_mcu9t5v0__endcap
* cell instance gf180mcu_fd_sc_mcu9t5v0__endcap_18 r0 *1 0,0
Xgf180mcu_fd_sc_mcu9t5v0__endcap_18 VDD VSS gf180mcu_fd_sc_mcu9t5v0__endcap
* cell instance gf180mcu_fd_sc_mcu9t5v0__endcap_19 r0 *1 0,0
Xgf180mcu_fd_sc_mcu9t5v0__endcap_19 VDD VSS gf180mcu_fd_sc_mcu9t5v0__endcap
* cell instance gf180mcu_fd_sc_mcu9t5v0__endcap_20 r0 *1 0,0
Xgf180mcu_fd_sc_mcu9t5v0__endcap_20 VDD VSS gf180mcu_fd_sc_mcu9t5v0__endcap
* cell instance gf180mcu_fd_sc_mcu9t5v0__endcap_21 r0 *1 0,0
Xgf180mcu_fd_sc_mcu9t5v0__endcap_21 VDD VSS gf180mcu_fd_sc_mcu9t5v0__endcap
* cell instance gf180mcu_fd_sc_mcu9t5v0__endcap_22 r0 *1 0,0
Xgf180mcu_fd_sc_mcu9t5v0__endcap_22 VDD VSS gf180mcu_fd_sc_mcu9t5v0__endcap
* cell instance gf180mcu_fd_sc_mcu9t5v0__endcap_23 r0 *1 0,0
Xgf180mcu_fd_sc_mcu9t5v0__endcap_23 VDD VSS gf180mcu_fd_sc_mcu9t5v0__endcap
* cell instance gf180mcu_fd_sc_mcu9t5v0__endcap_24 r0 *1 0,0
Xgf180mcu_fd_sc_mcu9t5v0__endcap_24 VDD VSS gf180mcu_fd_sc_mcu9t5v0__endcap
* cell instance gf180mcu_fd_sc_mcu9t5v0__endcap_25 r0 *1 0,0
Xgf180mcu_fd_sc_mcu9t5v0__endcap_25 VDD VSS gf180mcu_fd_sc_mcu9t5v0__endcap
* cell instance gf180mcu_fd_sc_mcu9t5v0__endcap_26 r0 *1 0,0
Xgf180mcu_fd_sc_mcu9t5v0__endcap_26 VDD VSS gf180mcu_fd_sc_mcu9t5v0__endcap
* cell instance gf180mcu_fd_sc_mcu9t5v0__endcap_27 r0 *1 0,0
Xgf180mcu_fd_sc_mcu9t5v0__endcap_27 VDD VSS gf180mcu_fd_sc_mcu9t5v0__endcap
* cell instance gf180mcu_fd_sc_mcu9t5v0__endcap_28 r0 *1 0,0
Xgf180mcu_fd_sc_mcu9t5v0__endcap_28 VDD VSS gf180mcu_fd_sc_mcu9t5v0__endcap
* cell instance gf180mcu_fd_sc_mcu9t5v0__endcap_29 r0 *1 0,0
Xgf180mcu_fd_sc_mcu9t5v0__endcap_29 VDD VSS gf180mcu_fd_sc_mcu9t5v0__endcap
* cell instance gf180mcu_fd_sc_mcu9t5v0__endcap_30 r0 *1 0,0
Xgf180mcu_fd_sc_mcu9t5v0__endcap_30 VDD VSS gf180mcu_fd_sc_mcu9t5v0__endcap
* cell instance gf180mcu_fd_sc_mcu9t5v0__endcap_31 r0 *1 0,0
Xgf180mcu_fd_sc_mcu9t5v0__endcap_31 VDD VSS gf180mcu_fd_sc_mcu9t5v0__endcap
* cell instance gf180mcu_fd_sc_mcu9t5v0__endcap_32 r0 *1 0,0
Xgf180mcu_fd_sc_mcu9t5v0__endcap_32 VDD VSS gf180mcu_fd_sc_mcu9t5v0__endcap
* cell instance gf180mcu_fd_sc_mcu9t5v0__endcap_33 r0 *1 0,0
Xgf180mcu_fd_sc_mcu9t5v0__endcap_33 VDD VSS gf180mcu_fd_sc_mcu9t5v0__endcap
* cell instance gf180mcu_fd_sc_mcu9t5v0__endcap_34 r0 *1 0,0
Xgf180mcu_fd_sc_mcu9t5v0__endcap_34 VDD VSS gf180mcu_fd_sc_mcu9t5v0__endcap
* cell instance gf180mcu_fd_sc_mcu9t5v0__endcap_35 r0 *1 0,0
Xgf180mcu_fd_sc_mcu9t5v0__endcap_35 VDD VSS gf180mcu_fd_sc_mcu9t5v0__endcap
* cell instance gf180mcu_fd_sc_mcu9t5v0__endcap_36 r0 *1 0,0
Xgf180mcu_fd_sc_mcu9t5v0__endcap_36 VDD VSS gf180mcu_fd_sc_mcu9t5v0__endcap
* cell instance gf180mcu_fd_sc_mcu9t5v0__endcap_37 r0 *1 0,0
Xgf180mcu_fd_sc_mcu9t5v0__endcap_37 VDD VSS gf180mcu_fd_sc_mcu9t5v0__endcap
* cell instance gf180mcu_fd_sc_mcu9t5v0__endcap_38 r0 *1 0,0
Xgf180mcu_fd_sc_mcu9t5v0__endcap_38 VDD VSS gf180mcu_fd_sc_mcu9t5v0__endcap
* cell instance gf180mcu_fd_sc_mcu9t5v0__endcap_39 r0 *1 0,0
Xgf180mcu_fd_sc_mcu9t5v0__endcap_39 VDD VSS gf180mcu_fd_sc_mcu9t5v0__endcap
* cell instance gf180mcu_fd_sc_mcu9t5v0__endcap_40 r0 *1 0,0
Xgf180mcu_fd_sc_mcu9t5v0__endcap_40 VDD VSS gf180mcu_fd_sc_mcu9t5v0__endcap
* cell instance gf180mcu_fd_sc_mcu9t5v0__endcap_41 r0 *1 0,0
Xgf180mcu_fd_sc_mcu9t5v0__endcap_41 VDD VSS gf180mcu_fd_sc_mcu9t5v0__endcap
* cell instance gf180mcu_fd_sc_mcu9t5v0__endcap_42 r0 *1 0,0
Xgf180mcu_fd_sc_mcu9t5v0__endcap_42 VDD VSS gf180mcu_fd_sc_mcu9t5v0__endcap
* cell instance gf180mcu_fd_sc_mcu9t5v0__endcap_43 r0 *1 0,0
Xgf180mcu_fd_sc_mcu9t5v0__endcap_43 VDD VSS gf180mcu_fd_sc_mcu9t5v0__endcap
* cell instance gf180mcu_fd_sc_mcu9t5v0__endcap_44 r0 *1 0,0
Xgf180mcu_fd_sc_mcu9t5v0__endcap_44 VDD VSS gf180mcu_fd_sc_mcu9t5v0__endcap
* cell instance gf180mcu_fd_sc_mcu9t5v0__endcap_45 r0 *1 0,0
Xgf180mcu_fd_sc_mcu9t5v0__endcap_45 VDD VSS gf180mcu_fd_sc_mcu9t5v0__endcap
* cell instance gf180mcu_fd_sc_mcu9t5v0__endcap_46 r0 *1 0,0
Xgf180mcu_fd_sc_mcu9t5v0__endcap_46 VDD VSS gf180mcu_fd_sc_mcu9t5v0__endcap
* cell instance gf180mcu_fd_sc_mcu9t5v0__endcap_47 r0 *1 0,0
Xgf180mcu_fd_sc_mcu9t5v0__endcap_47 VDD VSS gf180mcu_fd_sc_mcu9t5v0__endcap
* cell instance gf180mcu_fd_sc_mcu9t5v0__endcap_48 r0 *1 0,0
Xgf180mcu_fd_sc_mcu9t5v0__endcap_48 VDD VSS gf180mcu_fd_sc_mcu9t5v0__endcap
* cell instance gf180mcu_fd_sc_mcu9t5v0__endcap_49 r0 *1 0,0
Xgf180mcu_fd_sc_mcu9t5v0__endcap_49 VDD VSS gf180mcu_fd_sc_mcu9t5v0__endcap
* cell instance gf180mcu_fd_sc_mcu9t5v0__endcap_50 r0 *1 0,0
Xgf180mcu_fd_sc_mcu9t5v0__endcap_50 VDD VSS gf180mcu_fd_sc_mcu9t5v0__endcap
* cell instance gf180mcu_fd_sc_mcu9t5v0__endcap_51 r0 *1 0,0
Xgf180mcu_fd_sc_mcu9t5v0__endcap_51 VDD VSS gf180mcu_fd_sc_mcu9t5v0__endcap
* cell instance gf180mcu_fd_sc_mcu9t5v0__endcap_52 r0 *1 0,0
Xgf180mcu_fd_sc_mcu9t5v0__endcap_52 VDD VSS gf180mcu_fd_sc_mcu9t5v0__endcap
* cell instance gf180mcu_fd_sc_mcu9t5v0__endcap_53 r0 *1 0,0
Xgf180mcu_fd_sc_mcu9t5v0__endcap_53 VDD VSS gf180mcu_fd_sc_mcu9t5v0__endcap
* cell instance gf180mcu_fd_sc_mcu9t5v0__endcap_54 r0 *1 0,0
Xgf180mcu_fd_sc_mcu9t5v0__endcap_54 VDD VSS gf180mcu_fd_sc_mcu9t5v0__endcap
* cell instance gf180mcu_fd_sc_mcu9t5v0__endcap_55 r0 *1 0,0
Xgf180mcu_fd_sc_mcu9t5v0__endcap_55 VDD VSS gf180mcu_fd_sc_mcu9t5v0__endcap
* cell instance gf180mcu_fd_sc_mcu9t5v0__endcap_56 r0 *1 0,0
Xgf180mcu_fd_sc_mcu9t5v0__endcap_56 VDD VSS gf180mcu_fd_sc_mcu9t5v0__endcap
* cell instance gf180mcu_fd_sc_mcu9t5v0__endcap_57 r0 *1 0,0
Xgf180mcu_fd_sc_mcu9t5v0__endcap_57 VDD VSS gf180mcu_fd_sc_mcu9t5v0__endcap
* cell instance gf180mcu_fd_sc_mcu9t5v0__endcap_58 r0 *1 0,0
Xgf180mcu_fd_sc_mcu9t5v0__endcap_58 VDD VSS gf180mcu_fd_sc_mcu9t5v0__endcap
* cell instance gf180mcu_fd_sc_mcu9t5v0__endcap_59 r0 *1 0,0
Xgf180mcu_fd_sc_mcu9t5v0__endcap_59 VDD VSS gf180mcu_fd_sc_mcu9t5v0__endcap
* cell instance gf180mcu_fd_sc_mcu9t5v0__endcap_60 r0 *1 0,0
Xgf180mcu_fd_sc_mcu9t5v0__endcap_60 VDD VSS gf180mcu_fd_sc_mcu9t5v0__endcap
* cell instance gf180mcu_fd_sc_mcu9t5v0__endcap_61 r0 *1 0,0
Xgf180mcu_fd_sc_mcu9t5v0__endcap_61 VDD VSS gf180mcu_fd_sc_mcu9t5v0__endcap
* cell instance gf180mcu_fd_sc_mcu9t5v0__endcap_62 r0 *1 0,0
Xgf180mcu_fd_sc_mcu9t5v0__endcap_62 VDD VSS gf180mcu_fd_sc_mcu9t5v0__endcap
* cell instance gf180mcu_fd_sc_mcu9t5v0__endcap_63 r0 *1 0,0
Xgf180mcu_fd_sc_mcu9t5v0__endcap_63 VDD VSS gf180mcu_fd_sc_mcu9t5v0__endcap
* cell instance gf180mcu_fd_sc_mcu9t5v0__endcap_64 r0 *1 0,0
Xgf180mcu_fd_sc_mcu9t5v0__endcap_64 VDD VSS gf180mcu_fd_sc_mcu9t5v0__endcap
* cell instance gf180mcu_fd_sc_mcu9t5v0__endcap_65 r0 *1 0,0
Xgf180mcu_fd_sc_mcu9t5v0__endcap_65 VDD VSS gf180mcu_fd_sc_mcu9t5v0__endcap
* cell instance gf180mcu_fd_sc_mcu9t5v0__endcap_66 r0 *1 0,0
Xgf180mcu_fd_sc_mcu9t5v0__endcap_66 VDD VSS gf180mcu_fd_sc_mcu9t5v0__endcap
* cell instance gf180mcu_fd_sc_mcu9t5v0__endcap_67 r0 *1 0,0
Xgf180mcu_fd_sc_mcu9t5v0__endcap_67 VDD VSS gf180mcu_fd_sc_mcu9t5v0__endcap
* cell instance gf180mcu_fd_sc_mcu9t5v0__endcap_68 r0 *1 0,0
Xgf180mcu_fd_sc_mcu9t5v0__endcap_68 VDD VSS gf180mcu_fd_sc_mcu9t5v0__endcap
* cell instance gf180mcu_fd_sc_mcu9t5v0__endcap_69 r0 *1 0,0
Xgf180mcu_fd_sc_mcu9t5v0__endcap_69 VDD VSS gf180mcu_fd_sc_mcu9t5v0__endcap
* cell instance gf180mcu_fd_sc_mcu9t5v0__fill_1_0 r0 *1 0,0
Xgf180mcu_fd_sc_mcu9t5v0__fill_1_0 VDD VSS gf180mcu_fd_sc_mcu9t5v0__fill_1
* cell instance gf180mcu_fd_sc_mcu9t5v0__fill_1_1 r0 *1 0,0
Xgf180mcu_fd_sc_mcu9t5v0__fill_1_1 VDD VSS gf180mcu_fd_sc_mcu9t5v0__fill_1
* cell instance gf180mcu_fd_sc_mcu9t5v0__fill_1_2 r0 *1 0,0
Xgf180mcu_fd_sc_mcu9t5v0__fill_1_2 VDD VSS gf180mcu_fd_sc_mcu9t5v0__fill_1
* cell instance gf180mcu_fd_sc_mcu9t5v0__fill_1_3 r0 *1 0,0
Xgf180mcu_fd_sc_mcu9t5v0__fill_1_3 VDD VSS gf180mcu_fd_sc_mcu9t5v0__fill_1
* cell instance gf180mcu_fd_sc_mcu9t5v0__fill_1_4 r0 *1 0,0
Xgf180mcu_fd_sc_mcu9t5v0__fill_1_4 VDD VSS gf180mcu_fd_sc_mcu9t5v0__fill_1
* cell instance gf180mcu_fd_sc_mcu9t5v0__fill_1_5 r0 *1 0,0
Xgf180mcu_fd_sc_mcu9t5v0__fill_1_5 VDD VSS gf180mcu_fd_sc_mcu9t5v0__fill_1
* cell instance gf180mcu_fd_sc_mcu9t5v0__fill_1_6 r0 *1 0,0
Xgf180mcu_fd_sc_mcu9t5v0__fill_1_6 VDD VSS gf180mcu_fd_sc_mcu9t5v0__fill_1
* cell instance gf180mcu_fd_sc_mcu9t5v0__fill_1_7 r0 *1 0,0
Xgf180mcu_fd_sc_mcu9t5v0__fill_1_7 VDD VSS gf180mcu_fd_sc_mcu9t5v0__fill_1
* cell instance gf180mcu_fd_sc_mcu9t5v0__fill_1_8 r0 *1 0,0
Xgf180mcu_fd_sc_mcu9t5v0__fill_1_8 VDD VSS gf180mcu_fd_sc_mcu9t5v0__fill_1
* cell instance gf180mcu_fd_sc_mcu9t5v0__fill_1_9 r0 *1 0,0
Xgf180mcu_fd_sc_mcu9t5v0__fill_1_9 VDD VSS gf180mcu_fd_sc_mcu9t5v0__fill_1
* cell instance gf180mcu_fd_sc_mcu9t5v0__fill_1_10 r0 *1 0,0
Xgf180mcu_fd_sc_mcu9t5v0__fill_1_10 VDD VSS gf180mcu_fd_sc_mcu9t5v0__fill_1
* cell instance gf180mcu_fd_sc_mcu9t5v0__fill_1_11 r0 *1 0,0
Xgf180mcu_fd_sc_mcu9t5v0__fill_1_11 VDD VSS gf180mcu_fd_sc_mcu9t5v0__fill_1
* cell instance gf180mcu_fd_sc_mcu9t5v0__fill_1_12 r0 *1 0,0
Xgf180mcu_fd_sc_mcu9t5v0__fill_1_12 VDD VSS gf180mcu_fd_sc_mcu9t5v0__fill_1
* cell instance gf180mcu_fd_sc_mcu9t5v0__fill_1_13 r0 *1 0,0
Xgf180mcu_fd_sc_mcu9t5v0__fill_1_13 VDD VSS gf180mcu_fd_sc_mcu9t5v0__fill_1
* cell instance gf180mcu_fd_sc_mcu9t5v0__fill_1_14 r0 *1 0,0
Xgf180mcu_fd_sc_mcu9t5v0__fill_1_14 VDD VSS gf180mcu_fd_sc_mcu9t5v0__fill_1
* cell instance gf180mcu_fd_sc_mcu9t5v0__fill_1_15 r0 *1 0,0
Xgf180mcu_fd_sc_mcu9t5v0__fill_1_15 VDD VSS gf180mcu_fd_sc_mcu9t5v0__fill_1
* cell instance gf180mcu_fd_sc_mcu9t5v0__fill_1_16 r0 *1 0,0
Xgf180mcu_fd_sc_mcu9t5v0__fill_1_16 VDD VSS gf180mcu_fd_sc_mcu9t5v0__fill_1
* cell instance gf180mcu_fd_sc_mcu9t5v0__fill_1_17 r0 *1 0,0
Xgf180mcu_fd_sc_mcu9t5v0__fill_1_17 VDD VSS gf180mcu_fd_sc_mcu9t5v0__fill_1
* cell instance gf180mcu_fd_sc_mcu9t5v0__fill_1_18 r0 *1 0,0
Xgf180mcu_fd_sc_mcu9t5v0__fill_1_18 VDD VSS gf180mcu_fd_sc_mcu9t5v0__fill_1
* cell instance gf180mcu_fd_sc_mcu9t5v0__fill_1_19 r0 *1 0,0
Xgf180mcu_fd_sc_mcu9t5v0__fill_1_19 VDD VSS gf180mcu_fd_sc_mcu9t5v0__fill_1
* cell instance gf180mcu_fd_sc_mcu9t5v0__fill_1_20 r0 *1 0,0
Xgf180mcu_fd_sc_mcu9t5v0__fill_1_20 VDD VSS gf180mcu_fd_sc_mcu9t5v0__fill_1
* cell instance gf180mcu_fd_sc_mcu9t5v0__fill_1_21 r0 *1 0,0
Xgf180mcu_fd_sc_mcu9t5v0__fill_1_21 VDD VSS gf180mcu_fd_sc_mcu9t5v0__fill_1
* cell instance gf180mcu_fd_sc_mcu9t5v0__fill_1_22 r0 *1 0,0
Xgf180mcu_fd_sc_mcu9t5v0__fill_1_22 VDD VSS gf180mcu_fd_sc_mcu9t5v0__fill_1
* cell instance gf180mcu_fd_sc_mcu9t5v0__fill_1_23 r0 *1 0,0
Xgf180mcu_fd_sc_mcu9t5v0__fill_1_23 VDD VSS gf180mcu_fd_sc_mcu9t5v0__fill_1
* cell instance gf180mcu_fd_sc_mcu9t5v0__fill_1_24 r0 *1 0,0
Xgf180mcu_fd_sc_mcu9t5v0__fill_1_24 VDD VSS gf180mcu_fd_sc_mcu9t5v0__fill_1
* cell instance gf180mcu_fd_sc_mcu9t5v0__fill_1_25 r0 *1 0,0
Xgf180mcu_fd_sc_mcu9t5v0__fill_1_25 VDD VSS gf180mcu_fd_sc_mcu9t5v0__fill_1
* cell instance gf180mcu_fd_sc_mcu9t5v0__fill_1_26 r0 *1 0,0
Xgf180mcu_fd_sc_mcu9t5v0__fill_1_26 VDD VSS gf180mcu_fd_sc_mcu9t5v0__fill_1
* cell instance gf180mcu_fd_sc_mcu9t5v0__fill_1_27 r0 *1 0,0
Xgf180mcu_fd_sc_mcu9t5v0__fill_1_27 VDD VSS gf180mcu_fd_sc_mcu9t5v0__fill_1
* cell instance gf180mcu_fd_sc_mcu9t5v0__fill_1_28 r0 *1 0,0
Xgf180mcu_fd_sc_mcu9t5v0__fill_1_28 VDD VSS gf180mcu_fd_sc_mcu9t5v0__fill_1
* cell instance gf180mcu_fd_sc_mcu9t5v0__fill_1_29 r0 *1 0,0
Xgf180mcu_fd_sc_mcu9t5v0__fill_1_29 VDD VSS gf180mcu_fd_sc_mcu9t5v0__fill_1
* cell instance gf180mcu_fd_sc_mcu9t5v0__fill_1_30 r0 *1 0,0
Xgf180mcu_fd_sc_mcu9t5v0__fill_1_30 VDD VSS gf180mcu_fd_sc_mcu9t5v0__fill_1
* cell instance gf180mcu_fd_sc_mcu9t5v0__fill_1_31 r0 *1 0,0
Xgf180mcu_fd_sc_mcu9t5v0__fill_1_31 VDD VSS gf180mcu_fd_sc_mcu9t5v0__fill_1
* cell instance gf180mcu_fd_sc_mcu9t5v0__fill_1_32 r0 *1 0,0
Xgf180mcu_fd_sc_mcu9t5v0__fill_1_32 VDD VSS gf180mcu_fd_sc_mcu9t5v0__fill_1
* cell instance gf180mcu_fd_sc_mcu9t5v0__fill_1_33 r0 *1 0,0
Xgf180mcu_fd_sc_mcu9t5v0__fill_1_33 VDD VSS gf180mcu_fd_sc_mcu9t5v0__fill_1
* cell instance gf180mcu_fd_sc_mcu9t5v0__fill_1_34 r0 *1 0,0
Xgf180mcu_fd_sc_mcu9t5v0__fill_1_34 VDD VSS gf180mcu_fd_sc_mcu9t5v0__fill_1
* cell instance gf180mcu_fd_sc_mcu9t5v0__fill_1_35 r0 *1 0,0
Xgf180mcu_fd_sc_mcu9t5v0__fill_1_35 VDD VSS gf180mcu_fd_sc_mcu9t5v0__fill_1
* cell instance gf180mcu_fd_sc_mcu9t5v0__fill_1_36 r0 *1 0,0
Xgf180mcu_fd_sc_mcu9t5v0__fill_1_36 VDD VSS gf180mcu_fd_sc_mcu9t5v0__fill_1
* cell instance gf180mcu_fd_sc_mcu9t5v0__fill_1_37 r0 *1 0,0
Xgf180mcu_fd_sc_mcu9t5v0__fill_1_37 VDD VSS gf180mcu_fd_sc_mcu9t5v0__fill_1
* cell instance gf180mcu_fd_sc_mcu9t5v0__fill_1_38 r0 *1 0,0
Xgf180mcu_fd_sc_mcu9t5v0__fill_1_38 VDD VSS gf180mcu_fd_sc_mcu9t5v0__fill_1
* cell instance gf180mcu_fd_sc_mcu9t5v0__fill_1_39 r0 *1 0,0
Xgf180mcu_fd_sc_mcu9t5v0__fill_1_39 VDD VSS gf180mcu_fd_sc_mcu9t5v0__fill_1
* cell instance gf180mcu_fd_sc_mcu9t5v0__fill_1_40 r0 *1 0,0
Xgf180mcu_fd_sc_mcu9t5v0__fill_1_40 VDD VSS gf180mcu_fd_sc_mcu9t5v0__fill_1
* cell instance gf180mcu_fd_sc_mcu9t5v0__fill_1_41 r0 *1 0,0
Xgf180mcu_fd_sc_mcu9t5v0__fill_1_41 VDD VSS gf180mcu_fd_sc_mcu9t5v0__fill_1
* cell instance gf180mcu_fd_sc_mcu9t5v0__fill_1_42 r0 *1 0,0
Xgf180mcu_fd_sc_mcu9t5v0__fill_1_42 VDD VSS gf180mcu_fd_sc_mcu9t5v0__fill_1
* cell instance gf180mcu_fd_sc_mcu9t5v0__fill_1_43 r0 *1 0,0
Xgf180mcu_fd_sc_mcu9t5v0__fill_1_43 VDD VSS gf180mcu_fd_sc_mcu9t5v0__fill_1
* cell instance gf180mcu_fd_sc_mcu9t5v0__fill_1_44 r0 *1 0,0
Xgf180mcu_fd_sc_mcu9t5v0__fill_1_44 VDD VSS gf180mcu_fd_sc_mcu9t5v0__fill_1
* cell instance gf180mcu_fd_sc_mcu9t5v0__fill_1_45 r0 *1 0,0
Xgf180mcu_fd_sc_mcu9t5v0__fill_1_45 VDD VSS gf180mcu_fd_sc_mcu9t5v0__fill_1
* cell instance gf180mcu_fd_sc_mcu9t5v0__fill_1_46 r0 *1 0,0
Xgf180mcu_fd_sc_mcu9t5v0__fill_1_46 VDD VSS gf180mcu_fd_sc_mcu9t5v0__fill_1
* cell instance gf180mcu_fd_sc_mcu9t5v0__fill_1_47 r0 *1 0,0
Xgf180mcu_fd_sc_mcu9t5v0__fill_1_47 VDD VSS gf180mcu_fd_sc_mcu9t5v0__fill_1
* cell instance gf180mcu_fd_sc_mcu9t5v0__fill_1_48 r0 *1 0,0
Xgf180mcu_fd_sc_mcu9t5v0__fill_1_48 VDD VSS gf180mcu_fd_sc_mcu9t5v0__fill_1
* cell instance gf180mcu_fd_sc_mcu9t5v0__fill_1_49 r0 *1 0,0
Xgf180mcu_fd_sc_mcu9t5v0__fill_1_49 VDD VSS gf180mcu_fd_sc_mcu9t5v0__fill_1
* cell instance gf180mcu_fd_sc_mcu9t5v0__fill_1_50 r0 *1 0,0
Xgf180mcu_fd_sc_mcu9t5v0__fill_1_50 VDD VSS gf180mcu_fd_sc_mcu9t5v0__fill_1
* cell instance gf180mcu_fd_sc_mcu9t5v0__fill_1_51 r0 *1 0,0
Xgf180mcu_fd_sc_mcu9t5v0__fill_1_51 VDD VSS gf180mcu_fd_sc_mcu9t5v0__fill_1
* cell instance gf180mcu_fd_sc_mcu9t5v0__fill_1_52 r0 *1 0,0
Xgf180mcu_fd_sc_mcu9t5v0__fill_1_52 VDD VSS gf180mcu_fd_sc_mcu9t5v0__fill_1
* cell instance gf180mcu_fd_sc_mcu9t5v0__fill_1_53 r0 *1 0,0
Xgf180mcu_fd_sc_mcu9t5v0__fill_1_53 VDD VSS gf180mcu_fd_sc_mcu9t5v0__fill_1
* cell instance gf180mcu_fd_sc_mcu9t5v0__fill_1_54 r0 *1 0,0
Xgf180mcu_fd_sc_mcu9t5v0__fill_1_54 VDD VSS gf180mcu_fd_sc_mcu9t5v0__fill_1
* cell instance gf180mcu_fd_sc_mcu9t5v0__fill_1_55 r0 *1 0,0
Xgf180mcu_fd_sc_mcu9t5v0__fill_1_55 VDD VSS gf180mcu_fd_sc_mcu9t5v0__fill_1
* cell instance gf180mcu_fd_sc_mcu9t5v0__fill_1_56 r0 *1 0,0
Xgf180mcu_fd_sc_mcu9t5v0__fill_1_56 VDD VSS gf180mcu_fd_sc_mcu9t5v0__fill_1
* cell instance gf180mcu_fd_sc_mcu9t5v0__fill_1_57 r0 *1 0,0
Xgf180mcu_fd_sc_mcu9t5v0__fill_1_57 VDD VSS gf180mcu_fd_sc_mcu9t5v0__fill_1
* cell instance gf180mcu_fd_sc_mcu9t5v0__fill_1_58 r0 *1 0,0
Xgf180mcu_fd_sc_mcu9t5v0__fill_1_58 VDD VSS gf180mcu_fd_sc_mcu9t5v0__fill_1
* cell instance gf180mcu_fd_sc_mcu9t5v0__fill_1_59 r0 *1 0,0
Xgf180mcu_fd_sc_mcu9t5v0__fill_1_59 VDD VSS gf180mcu_fd_sc_mcu9t5v0__fill_1
* cell instance gf180mcu_fd_sc_mcu9t5v0__fill_1_60 r0 *1 0,0
Xgf180mcu_fd_sc_mcu9t5v0__fill_1_60 VDD VSS gf180mcu_fd_sc_mcu9t5v0__fill_1
* cell instance gf180mcu_fd_sc_mcu9t5v0__fill_1_61 r0 *1 0,0
Xgf180mcu_fd_sc_mcu9t5v0__fill_1_61 VDD VSS gf180mcu_fd_sc_mcu9t5v0__fill_1
* cell instance gf180mcu_fd_sc_mcu9t5v0__fill_1_62 r0 *1 0,0
Xgf180mcu_fd_sc_mcu9t5v0__fill_1_62 VDD VSS gf180mcu_fd_sc_mcu9t5v0__fill_1
* cell instance gf180mcu_fd_sc_mcu9t5v0__fill_1_63 r0 *1 0,0
Xgf180mcu_fd_sc_mcu9t5v0__fill_1_63 VDD VSS gf180mcu_fd_sc_mcu9t5v0__fill_1
* cell instance gf180mcu_fd_sc_mcu9t5v0__fill_1_64 r0 *1 0,0
Xgf180mcu_fd_sc_mcu9t5v0__fill_1_64 VDD VSS gf180mcu_fd_sc_mcu9t5v0__fill_1
* cell instance gf180mcu_fd_sc_mcu9t5v0__fill_1_65 r0 *1 0,0
Xgf180mcu_fd_sc_mcu9t5v0__fill_1_65 VDD VSS gf180mcu_fd_sc_mcu9t5v0__fill_1
* cell instance gf180mcu_fd_sc_mcu9t5v0__fill_1_66 r0 *1 0,0
Xgf180mcu_fd_sc_mcu9t5v0__fill_1_66 VDD VSS gf180mcu_fd_sc_mcu9t5v0__fill_1
* cell instance gf180mcu_fd_sc_mcu9t5v0__fill_1_67 r0 *1 0,0
Xgf180mcu_fd_sc_mcu9t5v0__fill_1_67 VDD VSS gf180mcu_fd_sc_mcu9t5v0__fill_1
* cell instance gf180mcu_fd_sc_mcu9t5v0__fill_1_68 r0 *1 0,0
Xgf180mcu_fd_sc_mcu9t5v0__fill_1_68 VDD VSS gf180mcu_fd_sc_mcu9t5v0__fill_1
* cell instance gf180mcu_fd_sc_mcu9t5v0__fill_1_69 r0 *1 0,0
Xgf180mcu_fd_sc_mcu9t5v0__fill_1_69 VDD VSS gf180mcu_fd_sc_mcu9t5v0__fill_1
* cell instance gf180mcu_fd_sc_mcu9t5v0__fill_1_70 r0 *1 0,0
Xgf180mcu_fd_sc_mcu9t5v0__fill_1_70 VDD VSS gf180mcu_fd_sc_mcu9t5v0__fill_1
* cell instance gf180mcu_fd_sc_mcu9t5v0__fill_1_71 r0 *1 0,0
Xgf180mcu_fd_sc_mcu9t5v0__fill_1_71 VDD VSS gf180mcu_fd_sc_mcu9t5v0__fill_1
* cell instance gf180mcu_fd_sc_mcu9t5v0__fill_1_72 r0 *1 0,0
Xgf180mcu_fd_sc_mcu9t5v0__fill_1_72 VDD VSS gf180mcu_fd_sc_mcu9t5v0__fill_1
* cell instance gf180mcu_fd_sc_mcu9t5v0__fill_1_73 r0 *1 0,0
Xgf180mcu_fd_sc_mcu9t5v0__fill_1_73 VDD VSS gf180mcu_fd_sc_mcu9t5v0__fill_1
* cell instance gf180mcu_fd_sc_mcu9t5v0__fill_1_74 r0 *1 0,0
Xgf180mcu_fd_sc_mcu9t5v0__fill_1_74 VDD VSS gf180mcu_fd_sc_mcu9t5v0__fill_1
* cell instance gf180mcu_fd_sc_mcu9t5v0__fill_1_75 r0 *1 0,0
Xgf180mcu_fd_sc_mcu9t5v0__fill_1_75 VDD VSS gf180mcu_fd_sc_mcu9t5v0__fill_1
* cell instance gf180mcu_fd_sc_mcu9t5v0__fill_1_76 r0 *1 0,0
Xgf180mcu_fd_sc_mcu9t5v0__fill_1_76 VDD VSS gf180mcu_fd_sc_mcu9t5v0__fill_1
* cell instance gf180mcu_fd_sc_mcu9t5v0__fill_1_77 r0 *1 0,0
Xgf180mcu_fd_sc_mcu9t5v0__fill_1_77 VDD VSS gf180mcu_fd_sc_mcu9t5v0__fill_1
* cell instance gf180mcu_fd_sc_mcu9t5v0__fill_1_78 r0 *1 0,0
Xgf180mcu_fd_sc_mcu9t5v0__fill_1_78 VDD VSS gf180mcu_fd_sc_mcu9t5v0__fill_1
* cell instance gf180mcu_fd_sc_mcu9t5v0__fill_1_79 r0 *1 0,0
Xgf180mcu_fd_sc_mcu9t5v0__fill_1_79 VDD VSS gf180mcu_fd_sc_mcu9t5v0__fill_1
* cell instance gf180mcu_fd_sc_mcu9t5v0__fill_1_80 r0 *1 0,0
Xgf180mcu_fd_sc_mcu9t5v0__fill_1_80 VDD VSS gf180mcu_fd_sc_mcu9t5v0__fill_1
* cell instance gf180mcu_fd_sc_mcu9t5v0__fill_1_81 r0 *1 0,0
Xgf180mcu_fd_sc_mcu9t5v0__fill_1_81 VDD VSS gf180mcu_fd_sc_mcu9t5v0__fill_1
* cell instance gf180mcu_fd_sc_mcu9t5v0__fill_1_82 r0 *1 0,0
Xgf180mcu_fd_sc_mcu9t5v0__fill_1_82 VDD VSS gf180mcu_fd_sc_mcu9t5v0__fill_1
* cell instance gf180mcu_fd_sc_mcu9t5v0__fill_1_83 r0 *1 0,0
Xgf180mcu_fd_sc_mcu9t5v0__fill_1_83 VDD VSS gf180mcu_fd_sc_mcu9t5v0__fill_1
* cell instance gf180mcu_fd_sc_mcu9t5v0__fill_1_84 r0 *1 0,0
Xgf180mcu_fd_sc_mcu9t5v0__fill_1_84 VDD VSS gf180mcu_fd_sc_mcu9t5v0__fill_1
* cell instance gf180mcu_fd_sc_mcu9t5v0__fill_1_85 r0 *1 0,0
Xgf180mcu_fd_sc_mcu9t5v0__fill_1_85 VDD VSS gf180mcu_fd_sc_mcu9t5v0__fill_1
* cell instance gf180mcu_fd_sc_mcu9t5v0__fill_1_86 r0 *1 0,0
Xgf180mcu_fd_sc_mcu9t5v0__fill_1_86 VDD VSS gf180mcu_fd_sc_mcu9t5v0__fill_1
* cell instance gf180mcu_fd_sc_mcu9t5v0__fill_1_87 r0 *1 0,0
Xgf180mcu_fd_sc_mcu9t5v0__fill_1_87 VDD VSS gf180mcu_fd_sc_mcu9t5v0__fill_1
* cell instance gf180mcu_fd_sc_mcu9t5v0__fill_1_88 r0 *1 0,0
Xgf180mcu_fd_sc_mcu9t5v0__fill_1_88 VDD VSS gf180mcu_fd_sc_mcu9t5v0__fill_1
* cell instance gf180mcu_fd_sc_mcu9t5v0__fill_1_89 r0 *1 0,0
Xgf180mcu_fd_sc_mcu9t5v0__fill_1_89 VDD VSS gf180mcu_fd_sc_mcu9t5v0__fill_1
* cell instance gf180mcu_fd_sc_mcu9t5v0__fill_1_90 r0 *1 0,0
Xgf180mcu_fd_sc_mcu9t5v0__fill_1_90 VDD VSS gf180mcu_fd_sc_mcu9t5v0__fill_1
* cell instance gf180mcu_fd_sc_mcu9t5v0__fill_1_91 r0 *1 0,0
Xgf180mcu_fd_sc_mcu9t5v0__fill_1_91 VDD VSS gf180mcu_fd_sc_mcu9t5v0__fill_1
* cell instance gf180mcu_fd_sc_mcu9t5v0__fill_1_92 r0 *1 0,0
Xgf180mcu_fd_sc_mcu9t5v0__fill_1_92 VDD VSS gf180mcu_fd_sc_mcu9t5v0__fill_1
* cell instance gf180mcu_fd_sc_mcu9t5v0__fill_1_93 r0 *1 0,0
Xgf180mcu_fd_sc_mcu9t5v0__fill_1_93 VDD VSS gf180mcu_fd_sc_mcu9t5v0__fill_1
* cell instance gf180mcu_fd_sc_mcu9t5v0__fill_1_94 r0 *1 0,0
Xgf180mcu_fd_sc_mcu9t5v0__fill_1_94 VDD VSS gf180mcu_fd_sc_mcu9t5v0__fill_1
* cell instance gf180mcu_fd_sc_mcu9t5v0__fill_1_95 r0 *1 0,0
Xgf180mcu_fd_sc_mcu9t5v0__fill_1_95 VDD VSS gf180mcu_fd_sc_mcu9t5v0__fill_1
* cell instance gf180mcu_fd_sc_mcu9t5v0__fill_1_96 r0 *1 0,0
Xgf180mcu_fd_sc_mcu9t5v0__fill_1_96 VDD VSS gf180mcu_fd_sc_mcu9t5v0__fill_1
* cell instance gf180mcu_fd_sc_mcu9t5v0__fill_1_97 r0 *1 0,0
Xgf180mcu_fd_sc_mcu9t5v0__fill_1_97 VDD VSS gf180mcu_fd_sc_mcu9t5v0__fill_1
* cell instance gf180mcu_fd_sc_mcu9t5v0__fill_1_98 r0 *1 0,0
Xgf180mcu_fd_sc_mcu9t5v0__fill_1_98 VDD VSS gf180mcu_fd_sc_mcu9t5v0__fill_1
* cell instance gf180mcu_fd_sc_mcu9t5v0__fill_1_99 r0 *1 0,0
Xgf180mcu_fd_sc_mcu9t5v0__fill_1_99 VDD VSS gf180mcu_fd_sc_mcu9t5v0__fill_1
* cell instance gf180mcu_fd_sc_mcu9t5v0__fill_1_100 r0 *1 0,0
Xgf180mcu_fd_sc_mcu9t5v0__fill_1_100 VDD VSS gf180mcu_fd_sc_mcu9t5v0__fill_1
* cell instance gf180mcu_fd_sc_mcu9t5v0__fill_1_101 r0 *1 0,0
Xgf180mcu_fd_sc_mcu9t5v0__fill_1_101 VDD VSS gf180mcu_fd_sc_mcu9t5v0__fill_1
* cell instance gf180mcu_fd_sc_mcu9t5v0__fill_1_102 r0 *1 0,0
Xgf180mcu_fd_sc_mcu9t5v0__fill_1_102 VDD VSS gf180mcu_fd_sc_mcu9t5v0__fill_1
* cell instance gf180mcu_fd_sc_mcu9t5v0__fill_1_103 r0 *1 0,0
Xgf180mcu_fd_sc_mcu9t5v0__fill_1_103 VDD VSS gf180mcu_fd_sc_mcu9t5v0__fill_1
* cell instance gf180mcu_fd_sc_mcu9t5v0__fill_1_104 r0 *1 0,0
Xgf180mcu_fd_sc_mcu9t5v0__fill_1_104 VDD VSS gf180mcu_fd_sc_mcu9t5v0__fill_1
* cell instance gf180mcu_fd_sc_mcu9t5v0__fill_1_105 r0 *1 0,0
Xgf180mcu_fd_sc_mcu9t5v0__fill_1_105 VDD VSS gf180mcu_fd_sc_mcu9t5v0__fill_1
* cell instance gf180mcu_fd_sc_mcu9t5v0__fill_1_106 r0 *1 0,0
Xgf180mcu_fd_sc_mcu9t5v0__fill_1_106 VDD VSS gf180mcu_fd_sc_mcu9t5v0__fill_1
* cell instance gf180mcu_fd_sc_mcu9t5v0__fill_1_107 r0 *1 0,0
Xgf180mcu_fd_sc_mcu9t5v0__fill_1_107 VDD VSS gf180mcu_fd_sc_mcu9t5v0__fill_1
* cell instance gf180mcu_fd_sc_mcu9t5v0__fill_1_108 r0 *1 0,0
Xgf180mcu_fd_sc_mcu9t5v0__fill_1_108 VDD VSS gf180mcu_fd_sc_mcu9t5v0__fill_1
* cell instance gf180mcu_fd_sc_mcu9t5v0__fill_1_109 r0 *1 0,0
Xgf180mcu_fd_sc_mcu9t5v0__fill_1_109 VDD VSS gf180mcu_fd_sc_mcu9t5v0__fill_1
* cell instance gf180mcu_fd_sc_mcu9t5v0__fill_1_110 r0 *1 0,0
Xgf180mcu_fd_sc_mcu9t5v0__fill_1_110 VDD VSS gf180mcu_fd_sc_mcu9t5v0__fill_1
* cell instance gf180mcu_fd_sc_mcu9t5v0__fill_1_111 r0 *1 0,0
Xgf180mcu_fd_sc_mcu9t5v0__fill_1_111 VDD VSS gf180mcu_fd_sc_mcu9t5v0__fill_1
* cell instance gf180mcu_fd_sc_mcu9t5v0__fill_1_112 r0 *1 0,0
Xgf180mcu_fd_sc_mcu9t5v0__fill_1_112 VDD VSS gf180mcu_fd_sc_mcu9t5v0__fill_1
* cell instance gf180mcu_fd_sc_mcu9t5v0__fill_1_113 r0 *1 0,0
Xgf180mcu_fd_sc_mcu9t5v0__fill_1_113 VDD VSS gf180mcu_fd_sc_mcu9t5v0__fill_1
* cell instance gf180mcu_fd_sc_mcu9t5v0__fill_1_114 r0 *1 0,0
Xgf180mcu_fd_sc_mcu9t5v0__fill_1_114 VDD VSS gf180mcu_fd_sc_mcu9t5v0__fill_1
* cell instance gf180mcu_fd_sc_mcu9t5v0__fill_1_115 r0 *1 0,0
Xgf180mcu_fd_sc_mcu9t5v0__fill_1_115 VDD VSS gf180mcu_fd_sc_mcu9t5v0__fill_1
* cell instance gf180mcu_fd_sc_mcu9t5v0__fill_1_116 r0 *1 0,0
Xgf180mcu_fd_sc_mcu9t5v0__fill_1_116 VDD VSS gf180mcu_fd_sc_mcu9t5v0__fill_1
* cell instance gf180mcu_fd_sc_mcu9t5v0__fill_1_117 r0 *1 0,0
Xgf180mcu_fd_sc_mcu9t5v0__fill_1_117 VDD VSS gf180mcu_fd_sc_mcu9t5v0__fill_1
* cell instance gf180mcu_fd_sc_mcu9t5v0__fill_1_118 r0 *1 0,0
Xgf180mcu_fd_sc_mcu9t5v0__fill_1_118 VDD VSS gf180mcu_fd_sc_mcu9t5v0__fill_1
* cell instance gf180mcu_fd_sc_mcu9t5v0__fill_1_119 r0 *1 0,0
Xgf180mcu_fd_sc_mcu9t5v0__fill_1_119 VDD VSS gf180mcu_fd_sc_mcu9t5v0__fill_1
* cell instance gf180mcu_fd_sc_mcu9t5v0__fill_1_120 r0 *1 0,0
Xgf180mcu_fd_sc_mcu9t5v0__fill_1_120 VDD VSS gf180mcu_fd_sc_mcu9t5v0__fill_1
* cell instance gf180mcu_fd_sc_mcu9t5v0__fill_1_121 r0 *1 0,0
Xgf180mcu_fd_sc_mcu9t5v0__fill_1_121 VDD VSS gf180mcu_fd_sc_mcu9t5v0__fill_1
* cell instance gf180mcu_fd_sc_mcu9t5v0__fill_1_122 r0 *1 0,0
Xgf180mcu_fd_sc_mcu9t5v0__fill_1_122 VDD VSS gf180mcu_fd_sc_mcu9t5v0__fill_1
* cell instance gf180mcu_fd_sc_mcu9t5v0__fill_1_123 r0 *1 0,0
Xgf180mcu_fd_sc_mcu9t5v0__fill_1_123 VDD VSS gf180mcu_fd_sc_mcu9t5v0__fill_1
* cell instance gf180mcu_fd_sc_mcu9t5v0__fill_1_124 r0 *1 0,0
Xgf180mcu_fd_sc_mcu9t5v0__fill_1_124 VDD VSS gf180mcu_fd_sc_mcu9t5v0__fill_1
* cell instance gf180mcu_fd_sc_mcu9t5v0__fill_1_125 r0 *1 0,0
Xgf180mcu_fd_sc_mcu9t5v0__fill_1_125 VDD VSS gf180mcu_fd_sc_mcu9t5v0__fill_1
* cell instance gf180mcu_fd_sc_mcu9t5v0__fill_1_126 r0 *1 0,0
Xgf180mcu_fd_sc_mcu9t5v0__fill_1_126 VDD VSS gf180mcu_fd_sc_mcu9t5v0__fill_1
* cell instance gf180mcu_fd_sc_mcu9t5v0__fill_1_127 r0 *1 0,0
Xgf180mcu_fd_sc_mcu9t5v0__fill_1_127 VDD VSS gf180mcu_fd_sc_mcu9t5v0__fill_1
* cell instance gf180mcu_fd_sc_mcu9t5v0__fill_1_128 r0 *1 0,0
Xgf180mcu_fd_sc_mcu9t5v0__fill_1_128 VDD VSS gf180mcu_fd_sc_mcu9t5v0__fill_1
* cell instance gf180mcu_fd_sc_mcu9t5v0__fill_1_129 r0 *1 0,0
Xgf180mcu_fd_sc_mcu9t5v0__fill_1_129 VDD VSS gf180mcu_fd_sc_mcu9t5v0__fill_1
* cell instance gf180mcu_fd_sc_mcu9t5v0__fill_1_130 r0 *1 0,0
Xgf180mcu_fd_sc_mcu9t5v0__fill_1_130 VDD VSS gf180mcu_fd_sc_mcu9t5v0__fill_1
* cell instance gf180mcu_fd_sc_mcu9t5v0__fill_1_131 r0 *1 0,0
Xgf180mcu_fd_sc_mcu9t5v0__fill_1_131 VDD VSS gf180mcu_fd_sc_mcu9t5v0__fill_1
* cell instance gf180mcu_fd_sc_mcu9t5v0__fill_1_132 r0 *1 0,0
Xgf180mcu_fd_sc_mcu9t5v0__fill_1_132 VDD VSS gf180mcu_fd_sc_mcu9t5v0__fill_1
* cell instance gf180mcu_fd_sc_mcu9t5v0__fill_1_133 r0 *1 0,0
Xgf180mcu_fd_sc_mcu9t5v0__fill_1_133 VDD VSS gf180mcu_fd_sc_mcu9t5v0__fill_1
* cell instance gf180mcu_fd_sc_mcu9t5v0__fill_1_134 r0 *1 0,0
Xgf180mcu_fd_sc_mcu9t5v0__fill_1_134 VDD VSS gf180mcu_fd_sc_mcu9t5v0__fill_1
* cell instance gf180mcu_fd_sc_mcu9t5v0__fill_1_135 r0 *1 0,0
Xgf180mcu_fd_sc_mcu9t5v0__fill_1_135 VDD VSS gf180mcu_fd_sc_mcu9t5v0__fill_1
* cell instance gf180mcu_fd_sc_mcu9t5v0__fill_1_136 r0 *1 0,0
Xgf180mcu_fd_sc_mcu9t5v0__fill_1_136 VDD VSS gf180mcu_fd_sc_mcu9t5v0__fill_1
* cell instance gf180mcu_fd_sc_mcu9t5v0__fill_1_137 r0 *1 0,0
Xgf180mcu_fd_sc_mcu9t5v0__fill_1_137 VDD VSS gf180mcu_fd_sc_mcu9t5v0__fill_1
* cell instance gf180mcu_fd_sc_mcu9t5v0__fill_1_138 r0 *1 0,0
Xgf180mcu_fd_sc_mcu9t5v0__fill_1_138 VDD VSS gf180mcu_fd_sc_mcu9t5v0__fill_1
* cell instance gf180mcu_fd_sc_mcu9t5v0__fill_1_139 r0 *1 0,0
Xgf180mcu_fd_sc_mcu9t5v0__fill_1_139 VDD VSS gf180mcu_fd_sc_mcu9t5v0__fill_1
* cell instance gf180mcu_fd_sc_mcu9t5v0__fill_1_140 r0 *1 0,0
Xgf180mcu_fd_sc_mcu9t5v0__fill_1_140 VDD VSS gf180mcu_fd_sc_mcu9t5v0__fill_1
* cell instance gf180mcu_fd_sc_mcu9t5v0__fill_1_141 r0 *1 0,0
Xgf180mcu_fd_sc_mcu9t5v0__fill_1_141 VDD VSS gf180mcu_fd_sc_mcu9t5v0__fill_1
* cell instance gf180mcu_fd_sc_mcu9t5v0__fill_1_142 r0 *1 0,0
Xgf180mcu_fd_sc_mcu9t5v0__fill_1_142 VDD VSS gf180mcu_fd_sc_mcu9t5v0__fill_1
* cell instance gf180mcu_fd_sc_mcu9t5v0__fill_1_143 r0 *1 0,0
Xgf180mcu_fd_sc_mcu9t5v0__fill_1_143 VDD VSS gf180mcu_fd_sc_mcu9t5v0__fill_1
* cell instance gf180mcu_fd_sc_mcu9t5v0__fill_1_144 r0 *1 0,0
Xgf180mcu_fd_sc_mcu9t5v0__fill_1_144 VDD VSS gf180mcu_fd_sc_mcu9t5v0__fill_1
* cell instance gf180mcu_fd_sc_mcu9t5v0__fill_1_145 r0 *1 0,0
Xgf180mcu_fd_sc_mcu9t5v0__fill_1_145 VDD VSS gf180mcu_fd_sc_mcu9t5v0__fill_1
* cell instance gf180mcu_fd_sc_mcu9t5v0__fill_1_146 r0 *1 0,0
Xgf180mcu_fd_sc_mcu9t5v0__fill_1_146 VDD VSS gf180mcu_fd_sc_mcu9t5v0__fill_1
* cell instance gf180mcu_fd_sc_mcu9t5v0__fill_1_147 r0 *1 0,0
Xgf180mcu_fd_sc_mcu9t5v0__fill_1_147 VDD VSS gf180mcu_fd_sc_mcu9t5v0__fill_1
* cell instance gf180mcu_fd_sc_mcu9t5v0__fill_1_148 r0 *1 0,0
Xgf180mcu_fd_sc_mcu9t5v0__fill_1_148 VDD VSS gf180mcu_fd_sc_mcu9t5v0__fill_1
* cell instance gf180mcu_fd_sc_mcu9t5v0__fill_1_149 r0 *1 0,0
Xgf180mcu_fd_sc_mcu9t5v0__fill_1_149 VDD VSS gf180mcu_fd_sc_mcu9t5v0__fill_1
* cell instance gf180mcu_fd_sc_mcu9t5v0__fill_1_150 r0 *1 0,0
Xgf180mcu_fd_sc_mcu9t5v0__fill_1_150 VDD VSS gf180mcu_fd_sc_mcu9t5v0__fill_1
* cell instance gf180mcu_fd_sc_mcu9t5v0__fill_1_151 r0 *1 0,0
Xgf180mcu_fd_sc_mcu9t5v0__fill_1_151 VDD VSS gf180mcu_fd_sc_mcu9t5v0__fill_1
* cell instance gf180mcu_fd_sc_mcu9t5v0__fill_16_0 r0 *1 0,0
Xgf180mcu_fd_sc_mcu9t5v0__fill_16_0 VDD VSS gf180mcu_fd_sc_mcu9t5v0__fill_16
* cell instance gf180mcu_fd_sc_mcu9t5v0__fill_16_1 r0 *1 0,0
Xgf180mcu_fd_sc_mcu9t5v0__fill_16_1 VDD VSS gf180mcu_fd_sc_mcu9t5v0__fill_16
* cell instance gf180mcu_fd_sc_mcu9t5v0__fill_16_2 r0 *1 0,0
Xgf180mcu_fd_sc_mcu9t5v0__fill_16_2 VDD VSS gf180mcu_fd_sc_mcu9t5v0__fill_16
* cell instance gf180mcu_fd_sc_mcu9t5v0__fill_16_3 r0 *1 0,0
Xgf180mcu_fd_sc_mcu9t5v0__fill_16_3 VDD VSS gf180mcu_fd_sc_mcu9t5v0__fill_16
* cell instance gf180mcu_fd_sc_mcu9t5v0__fill_16_4 r0 *1 0,0
Xgf180mcu_fd_sc_mcu9t5v0__fill_16_4 VDD VSS gf180mcu_fd_sc_mcu9t5v0__fill_16
* cell instance gf180mcu_fd_sc_mcu9t5v0__fill_16_5 r0 *1 0,0
Xgf180mcu_fd_sc_mcu9t5v0__fill_16_5 VDD VSS gf180mcu_fd_sc_mcu9t5v0__fill_16
* cell instance gf180mcu_fd_sc_mcu9t5v0__fill_16_6 r0 *1 0,0
Xgf180mcu_fd_sc_mcu9t5v0__fill_16_6 VDD VSS gf180mcu_fd_sc_mcu9t5v0__fill_16
* cell instance gf180mcu_fd_sc_mcu9t5v0__fill_16_7 r0 *1 0,0
Xgf180mcu_fd_sc_mcu9t5v0__fill_16_7 VDD VSS gf180mcu_fd_sc_mcu9t5v0__fill_16
* cell instance gf180mcu_fd_sc_mcu9t5v0__fill_16_8 r0 *1 0,0
Xgf180mcu_fd_sc_mcu9t5v0__fill_16_8 VDD VSS gf180mcu_fd_sc_mcu9t5v0__fill_16
* cell instance gf180mcu_fd_sc_mcu9t5v0__fill_16_9 r0 *1 0,0
Xgf180mcu_fd_sc_mcu9t5v0__fill_16_9 VDD VSS gf180mcu_fd_sc_mcu9t5v0__fill_16
* cell instance gf180mcu_fd_sc_mcu9t5v0__fill_16_10 r0 *1 0,0
Xgf180mcu_fd_sc_mcu9t5v0__fill_16_10 VDD VSS gf180mcu_fd_sc_mcu9t5v0__fill_16
* cell instance gf180mcu_fd_sc_mcu9t5v0__fill_16_11 r0 *1 0,0
Xgf180mcu_fd_sc_mcu9t5v0__fill_16_11 VDD VSS gf180mcu_fd_sc_mcu9t5v0__fill_16
* cell instance gf180mcu_fd_sc_mcu9t5v0__fill_16_12 r0 *1 0,0
Xgf180mcu_fd_sc_mcu9t5v0__fill_16_12 VDD VSS gf180mcu_fd_sc_mcu9t5v0__fill_16
* cell instance gf180mcu_fd_sc_mcu9t5v0__fill_16_13 r0 *1 0,0
Xgf180mcu_fd_sc_mcu9t5v0__fill_16_13 VDD VSS gf180mcu_fd_sc_mcu9t5v0__fill_16
* cell instance gf180mcu_fd_sc_mcu9t5v0__fill_16_14 r0 *1 0,0
Xgf180mcu_fd_sc_mcu9t5v0__fill_16_14 VDD VSS gf180mcu_fd_sc_mcu9t5v0__fill_16
* cell instance gf180mcu_fd_sc_mcu9t5v0__fill_16_15 r0 *1 0,0
Xgf180mcu_fd_sc_mcu9t5v0__fill_16_15 VDD VSS gf180mcu_fd_sc_mcu9t5v0__fill_16
* cell instance gf180mcu_fd_sc_mcu9t5v0__fill_16_16 r0 *1 0,0
Xgf180mcu_fd_sc_mcu9t5v0__fill_16_16 VDD VSS gf180mcu_fd_sc_mcu9t5v0__fill_16
* cell instance gf180mcu_fd_sc_mcu9t5v0__fill_16_17 r0 *1 0,0
Xgf180mcu_fd_sc_mcu9t5v0__fill_16_17 VDD VSS gf180mcu_fd_sc_mcu9t5v0__fill_16
* cell instance gf180mcu_fd_sc_mcu9t5v0__fill_16_18 r0 *1 0,0
Xgf180mcu_fd_sc_mcu9t5v0__fill_16_18 VDD VSS gf180mcu_fd_sc_mcu9t5v0__fill_16
* cell instance gf180mcu_fd_sc_mcu9t5v0__fill_16_19 r0 *1 0,0
Xgf180mcu_fd_sc_mcu9t5v0__fill_16_19 VDD VSS gf180mcu_fd_sc_mcu9t5v0__fill_16
* cell instance gf180mcu_fd_sc_mcu9t5v0__fill_16_20 r0 *1 0,0
Xgf180mcu_fd_sc_mcu9t5v0__fill_16_20 VDD VSS gf180mcu_fd_sc_mcu9t5v0__fill_16
* cell instance gf180mcu_fd_sc_mcu9t5v0__fill_16_21 r0 *1 0,0
Xgf180mcu_fd_sc_mcu9t5v0__fill_16_21 VDD VSS gf180mcu_fd_sc_mcu9t5v0__fill_16
* cell instance gf180mcu_fd_sc_mcu9t5v0__fill_16_22 r0 *1 0,0
Xgf180mcu_fd_sc_mcu9t5v0__fill_16_22 VDD VSS gf180mcu_fd_sc_mcu9t5v0__fill_16
* cell instance gf180mcu_fd_sc_mcu9t5v0__fill_16_23 r0 *1 0,0
Xgf180mcu_fd_sc_mcu9t5v0__fill_16_23 VDD VSS gf180mcu_fd_sc_mcu9t5v0__fill_16
* cell instance gf180mcu_fd_sc_mcu9t5v0__fill_16_24 r0 *1 0,0
Xgf180mcu_fd_sc_mcu9t5v0__fill_16_24 VDD VSS gf180mcu_fd_sc_mcu9t5v0__fill_16
* cell instance gf180mcu_fd_sc_mcu9t5v0__fill_16_25 r0 *1 0,0
Xgf180mcu_fd_sc_mcu9t5v0__fill_16_25 VDD VSS gf180mcu_fd_sc_mcu9t5v0__fill_16
* cell instance gf180mcu_fd_sc_mcu9t5v0__fill_16_26 r0 *1 0,0
Xgf180mcu_fd_sc_mcu9t5v0__fill_16_26 VDD VSS gf180mcu_fd_sc_mcu9t5v0__fill_16
* cell instance gf180mcu_fd_sc_mcu9t5v0__fill_16_27 r0 *1 0,0
Xgf180mcu_fd_sc_mcu9t5v0__fill_16_27 VDD VSS gf180mcu_fd_sc_mcu9t5v0__fill_16
* cell instance gf180mcu_fd_sc_mcu9t5v0__fill_16_28 r0 *1 0,0
Xgf180mcu_fd_sc_mcu9t5v0__fill_16_28 VDD VSS gf180mcu_fd_sc_mcu9t5v0__fill_16
* cell instance gf180mcu_fd_sc_mcu9t5v0__fill_16_29 r0 *1 0,0
Xgf180mcu_fd_sc_mcu9t5v0__fill_16_29 VDD VSS gf180mcu_fd_sc_mcu9t5v0__fill_16
* cell instance gf180mcu_fd_sc_mcu9t5v0__fill_16_30 r0 *1 0,0
Xgf180mcu_fd_sc_mcu9t5v0__fill_16_30 VDD VSS gf180mcu_fd_sc_mcu9t5v0__fill_16
* cell instance gf180mcu_fd_sc_mcu9t5v0__fill_16_31 r0 *1 0,0
Xgf180mcu_fd_sc_mcu9t5v0__fill_16_31 VDD VSS gf180mcu_fd_sc_mcu9t5v0__fill_16
* cell instance gf180mcu_fd_sc_mcu9t5v0__fill_16_32 r0 *1 0,0
Xgf180mcu_fd_sc_mcu9t5v0__fill_16_32 VDD VSS gf180mcu_fd_sc_mcu9t5v0__fill_16
* cell instance gf180mcu_fd_sc_mcu9t5v0__fill_16_33 r0 *1 0,0
Xgf180mcu_fd_sc_mcu9t5v0__fill_16_33 VDD VSS gf180mcu_fd_sc_mcu9t5v0__fill_16
* cell instance gf180mcu_fd_sc_mcu9t5v0__fill_16_34 r0 *1 0,0
Xgf180mcu_fd_sc_mcu9t5v0__fill_16_34 VDD VSS gf180mcu_fd_sc_mcu9t5v0__fill_16
* cell instance gf180mcu_fd_sc_mcu9t5v0__fill_16_35 r0 *1 0,0
Xgf180mcu_fd_sc_mcu9t5v0__fill_16_35 VDD VSS gf180mcu_fd_sc_mcu9t5v0__fill_16
* cell instance gf180mcu_fd_sc_mcu9t5v0__fill_16_36 r0 *1 0,0
Xgf180mcu_fd_sc_mcu9t5v0__fill_16_36 VDD VSS gf180mcu_fd_sc_mcu9t5v0__fill_16
* cell instance gf180mcu_fd_sc_mcu9t5v0__fill_16_37 r0 *1 0,0
Xgf180mcu_fd_sc_mcu9t5v0__fill_16_37 VDD VSS gf180mcu_fd_sc_mcu9t5v0__fill_16
* cell instance gf180mcu_fd_sc_mcu9t5v0__fill_16_38 r0 *1 0,0
Xgf180mcu_fd_sc_mcu9t5v0__fill_16_38 VDD VSS gf180mcu_fd_sc_mcu9t5v0__fill_16
* cell instance gf180mcu_fd_sc_mcu9t5v0__fill_16_39 r0 *1 0,0
Xgf180mcu_fd_sc_mcu9t5v0__fill_16_39 VDD VSS gf180mcu_fd_sc_mcu9t5v0__fill_16
* cell instance gf180mcu_fd_sc_mcu9t5v0__fill_16_40 r0 *1 0,0
Xgf180mcu_fd_sc_mcu9t5v0__fill_16_40 VDD VSS gf180mcu_fd_sc_mcu9t5v0__fill_16
* cell instance gf180mcu_fd_sc_mcu9t5v0__fill_16_41 r0 *1 0,0
Xgf180mcu_fd_sc_mcu9t5v0__fill_16_41 VDD VSS gf180mcu_fd_sc_mcu9t5v0__fill_16
* cell instance gf180mcu_fd_sc_mcu9t5v0__fill_16_42 r0 *1 0,0
Xgf180mcu_fd_sc_mcu9t5v0__fill_16_42 VDD VSS gf180mcu_fd_sc_mcu9t5v0__fill_16
* cell instance gf180mcu_fd_sc_mcu9t5v0__fill_16_43 r0 *1 0,0
Xgf180mcu_fd_sc_mcu9t5v0__fill_16_43 VDD VSS gf180mcu_fd_sc_mcu9t5v0__fill_16
* cell instance gf180mcu_fd_sc_mcu9t5v0__fill_16_44 r0 *1 0,0
Xgf180mcu_fd_sc_mcu9t5v0__fill_16_44 VDD VSS gf180mcu_fd_sc_mcu9t5v0__fill_16
* cell instance gf180mcu_fd_sc_mcu9t5v0__fill_16_45 r0 *1 0,0
Xgf180mcu_fd_sc_mcu9t5v0__fill_16_45 VDD VSS gf180mcu_fd_sc_mcu9t5v0__fill_16
* cell instance gf180mcu_fd_sc_mcu9t5v0__fill_16_46 r0 *1 0,0
Xgf180mcu_fd_sc_mcu9t5v0__fill_16_46 VDD VSS gf180mcu_fd_sc_mcu9t5v0__fill_16
* cell instance gf180mcu_fd_sc_mcu9t5v0__fill_16_47 r0 *1 0,0
Xgf180mcu_fd_sc_mcu9t5v0__fill_16_47 VDD VSS gf180mcu_fd_sc_mcu9t5v0__fill_16
* cell instance gf180mcu_fd_sc_mcu9t5v0__fill_16_48 r0 *1 0,0
Xgf180mcu_fd_sc_mcu9t5v0__fill_16_48 VDD VSS gf180mcu_fd_sc_mcu9t5v0__fill_16
* cell instance gf180mcu_fd_sc_mcu9t5v0__fill_16_49 r0 *1 0,0
Xgf180mcu_fd_sc_mcu9t5v0__fill_16_49 VDD VSS gf180mcu_fd_sc_mcu9t5v0__fill_16
* cell instance gf180mcu_fd_sc_mcu9t5v0__fill_16_50 r0 *1 0,0
Xgf180mcu_fd_sc_mcu9t5v0__fill_16_50 VDD VSS gf180mcu_fd_sc_mcu9t5v0__fill_16
* cell instance gf180mcu_fd_sc_mcu9t5v0__fill_16_51 r0 *1 0,0
Xgf180mcu_fd_sc_mcu9t5v0__fill_16_51 VDD VSS gf180mcu_fd_sc_mcu9t5v0__fill_16
* cell instance gf180mcu_fd_sc_mcu9t5v0__fill_16_52 r0 *1 0,0
Xgf180mcu_fd_sc_mcu9t5v0__fill_16_52 VDD VSS gf180mcu_fd_sc_mcu9t5v0__fill_16
* cell instance gf180mcu_fd_sc_mcu9t5v0__fill_16_53 r0 *1 0,0
Xgf180mcu_fd_sc_mcu9t5v0__fill_16_53 VDD VSS gf180mcu_fd_sc_mcu9t5v0__fill_16
* cell instance gf180mcu_fd_sc_mcu9t5v0__fill_16_54 r0 *1 0,0
Xgf180mcu_fd_sc_mcu9t5v0__fill_16_54 VDD VSS gf180mcu_fd_sc_mcu9t5v0__fill_16
* cell instance gf180mcu_fd_sc_mcu9t5v0__fill_16_55 r0 *1 0,0
Xgf180mcu_fd_sc_mcu9t5v0__fill_16_55 VDD VSS gf180mcu_fd_sc_mcu9t5v0__fill_16
* cell instance gf180mcu_fd_sc_mcu9t5v0__fill_16_56 r0 *1 0,0
Xgf180mcu_fd_sc_mcu9t5v0__fill_16_56 VDD VSS gf180mcu_fd_sc_mcu9t5v0__fill_16
* cell instance gf180mcu_fd_sc_mcu9t5v0__fill_16_57 r0 *1 0,0
Xgf180mcu_fd_sc_mcu9t5v0__fill_16_57 VDD VSS gf180mcu_fd_sc_mcu9t5v0__fill_16
* cell instance gf180mcu_fd_sc_mcu9t5v0__fill_16_58 r0 *1 0,0
Xgf180mcu_fd_sc_mcu9t5v0__fill_16_58 VDD VSS gf180mcu_fd_sc_mcu9t5v0__fill_16
* cell instance gf180mcu_fd_sc_mcu9t5v0__fill_16_59 r0 *1 0,0
Xgf180mcu_fd_sc_mcu9t5v0__fill_16_59 VDD VSS gf180mcu_fd_sc_mcu9t5v0__fill_16
* cell instance gf180mcu_fd_sc_mcu9t5v0__fill_16_60 r0 *1 0,0
Xgf180mcu_fd_sc_mcu9t5v0__fill_16_60 VDD VSS gf180mcu_fd_sc_mcu9t5v0__fill_16
* cell instance gf180mcu_fd_sc_mcu9t5v0__fill_16_61 r0 *1 0,0
Xgf180mcu_fd_sc_mcu9t5v0__fill_16_61 VDD VSS gf180mcu_fd_sc_mcu9t5v0__fill_16
* cell instance gf180mcu_fd_sc_mcu9t5v0__fill_16_62 r0 *1 0,0
Xgf180mcu_fd_sc_mcu9t5v0__fill_16_62 VDD VSS gf180mcu_fd_sc_mcu9t5v0__fill_16
* cell instance gf180mcu_fd_sc_mcu9t5v0__fill_16_63 r0 *1 0,0
Xgf180mcu_fd_sc_mcu9t5v0__fill_16_63 VDD VSS gf180mcu_fd_sc_mcu9t5v0__fill_16
* cell instance gf180mcu_fd_sc_mcu9t5v0__fill_16_64 r0 *1 0,0
Xgf180mcu_fd_sc_mcu9t5v0__fill_16_64 VDD VSS gf180mcu_fd_sc_mcu9t5v0__fill_16
* cell instance gf180mcu_fd_sc_mcu9t5v0__fill_16_65 r0 *1 0,0
Xgf180mcu_fd_sc_mcu9t5v0__fill_16_65 VDD VSS gf180mcu_fd_sc_mcu9t5v0__fill_16
* cell instance gf180mcu_fd_sc_mcu9t5v0__fill_16_66 r0 *1 0,0
Xgf180mcu_fd_sc_mcu9t5v0__fill_16_66 VDD VSS gf180mcu_fd_sc_mcu9t5v0__fill_16
* cell instance gf180mcu_fd_sc_mcu9t5v0__fill_16_67 r0 *1 0,0
Xgf180mcu_fd_sc_mcu9t5v0__fill_16_67 VDD VSS gf180mcu_fd_sc_mcu9t5v0__fill_16
* cell instance gf180mcu_fd_sc_mcu9t5v0__fill_16_68 r0 *1 0,0
Xgf180mcu_fd_sc_mcu9t5v0__fill_16_68 VDD VSS gf180mcu_fd_sc_mcu9t5v0__fill_16
* cell instance gf180mcu_fd_sc_mcu9t5v0__fill_16_69 r0 *1 0,0
Xgf180mcu_fd_sc_mcu9t5v0__fill_16_69 VDD VSS gf180mcu_fd_sc_mcu9t5v0__fill_16
* cell instance gf180mcu_fd_sc_mcu9t5v0__fill_16_70 r0 *1 0,0
Xgf180mcu_fd_sc_mcu9t5v0__fill_16_70 VDD VSS gf180mcu_fd_sc_mcu9t5v0__fill_16
* cell instance gf180mcu_fd_sc_mcu9t5v0__fill_16_71 r0 *1 0,0
Xgf180mcu_fd_sc_mcu9t5v0__fill_16_71 VDD VSS gf180mcu_fd_sc_mcu9t5v0__fill_16
* cell instance gf180mcu_fd_sc_mcu9t5v0__fill_16_72 r0 *1 0,0
Xgf180mcu_fd_sc_mcu9t5v0__fill_16_72 VDD VSS gf180mcu_fd_sc_mcu9t5v0__fill_16
* cell instance gf180mcu_fd_sc_mcu9t5v0__fill_16_73 r0 *1 0,0
Xgf180mcu_fd_sc_mcu9t5v0__fill_16_73 VDD VSS gf180mcu_fd_sc_mcu9t5v0__fill_16
* cell instance gf180mcu_fd_sc_mcu9t5v0__fill_16_74 r0 *1 0,0
Xgf180mcu_fd_sc_mcu9t5v0__fill_16_74 VDD VSS gf180mcu_fd_sc_mcu9t5v0__fill_16
* cell instance gf180mcu_fd_sc_mcu9t5v0__fill_16_75 r0 *1 0,0
Xgf180mcu_fd_sc_mcu9t5v0__fill_16_75 VDD VSS gf180mcu_fd_sc_mcu9t5v0__fill_16
* cell instance gf180mcu_fd_sc_mcu9t5v0__fill_16_76 r0 *1 0,0
Xgf180mcu_fd_sc_mcu9t5v0__fill_16_76 VDD VSS gf180mcu_fd_sc_mcu9t5v0__fill_16
* cell instance gf180mcu_fd_sc_mcu9t5v0__fill_16_77 r0 *1 0,0
Xgf180mcu_fd_sc_mcu9t5v0__fill_16_77 VDD VSS gf180mcu_fd_sc_mcu9t5v0__fill_16
* cell instance gf180mcu_fd_sc_mcu9t5v0__fill_16_78 r0 *1 0,0
Xgf180mcu_fd_sc_mcu9t5v0__fill_16_78 VDD VSS gf180mcu_fd_sc_mcu9t5v0__fill_16
* cell instance gf180mcu_fd_sc_mcu9t5v0__fill_16_79 r0 *1 0,0
Xgf180mcu_fd_sc_mcu9t5v0__fill_16_79 VDD VSS gf180mcu_fd_sc_mcu9t5v0__fill_16
* cell instance gf180mcu_fd_sc_mcu9t5v0__fill_16_80 r0 *1 0,0
Xgf180mcu_fd_sc_mcu9t5v0__fill_16_80 VDD VSS gf180mcu_fd_sc_mcu9t5v0__fill_16
* cell instance gf180mcu_fd_sc_mcu9t5v0__fill_16_81 r0 *1 0,0
Xgf180mcu_fd_sc_mcu9t5v0__fill_16_81 VDD VSS gf180mcu_fd_sc_mcu9t5v0__fill_16
* cell instance gf180mcu_fd_sc_mcu9t5v0__fill_16_82 r0 *1 0,0
Xgf180mcu_fd_sc_mcu9t5v0__fill_16_82 VDD VSS gf180mcu_fd_sc_mcu9t5v0__fill_16
* cell instance gf180mcu_fd_sc_mcu9t5v0__fill_16_83 r0 *1 0,0
Xgf180mcu_fd_sc_mcu9t5v0__fill_16_83 VDD VSS gf180mcu_fd_sc_mcu9t5v0__fill_16
* cell instance gf180mcu_fd_sc_mcu9t5v0__fill_16_84 r0 *1 0,0
Xgf180mcu_fd_sc_mcu9t5v0__fill_16_84 VDD VSS gf180mcu_fd_sc_mcu9t5v0__fill_16
* cell instance gf180mcu_fd_sc_mcu9t5v0__fill_16_85 r0 *1 0,0
Xgf180mcu_fd_sc_mcu9t5v0__fill_16_85 VDD VSS gf180mcu_fd_sc_mcu9t5v0__fill_16
* cell instance gf180mcu_fd_sc_mcu9t5v0__fill_16_86 r0 *1 0,0
Xgf180mcu_fd_sc_mcu9t5v0__fill_16_86 VDD VSS gf180mcu_fd_sc_mcu9t5v0__fill_16
* cell instance gf180mcu_fd_sc_mcu9t5v0__fill_16_87 r0 *1 0,0
Xgf180mcu_fd_sc_mcu9t5v0__fill_16_87 VDD VSS gf180mcu_fd_sc_mcu9t5v0__fill_16
* cell instance gf180mcu_fd_sc_mcu9t5v0__fill_16_88 r0 *1 0,0
Xgf180mcu_fd_sc_mcu9t5v0__fill_16_88 VDD VSS gf180mcu_fd_sc_mcu9t5v0__fill_16
* cell instance gf180mcu_fd_sc_mcu9t5v0__fill_16_89 r0 *1 0,0
Xgf180mcu_fd_sc_mcu9t5v0__fill_16_89 VDD VSS gf180mcu_fd_sc_mcu9t5v0__fill_16
* cell instance gf180mcu_fd_sc_mcu9t5v0__fill_2_0 r0 *1 0,0
Xgf180mcu_fd_sc_mcu9t5v0__fill_2_0 VDD VSS gf180mcu_fd_sc_mcu9t5v0__fill_2
* cell instance gf180mcu_fd_sc_mcu9t5v0__fill_2_1 r0 *1 0,0
Xgf180mcu_fd_sc_mcu9t5v0__fill_2_1 VDD VSS gf180mcu_fd_sc_mcu9t5v0__fill_2
* cell instance gf180mcu_fd_sc_mcu9t5v0__fill_2_2 r0 *1 0,0
Xgf180mcu_fd_sc_mcu9t5v0__fill_2_2 VDD VSS gf180mcu_fd_sc_mcu9t5v0__fill_2
* cell instance gf180mcu_fd_sc_mcu9t5v0__fill_2_3 r0 *1 0,0
Xgf180mcu_fd_sc_mcu9t5v0__fill_2_3 VDD VSS gf180mcu_fd_sc_mcu9t5v0__fill_2
* cell instance gf180mcu_fd_sc_mcu9t5v0__fill_2_4 r0 *1 0,0
Xgf180mcu_fd_sc_mcu9t5v0__fill_2_4 VDD VSS gf180mcu_fd_sc_mcu9t5v0__fill_2
* cell instance gf180mcu_fd_sc_mcu9t5v0__fill_2_5 r0 *1 0,0
Xgf180mcu_fd_sc_mcu9t5v0__fill_2_5 VDD VSS gf180mcu_fd_sc_mcu9t5v0__fill_2
* cell instance gf180mcu_fd_sc_mcu9t5v0__fill_2_6 r0 *1 0,0
Xgf180mcu_fd_sc_mcu9t5v0__fill_2_6 VDD VSS gf180mcu_fd_sc_mcu9t5v0__fill_2
* cell instance gf180mcu_fd_sc_mcu9t5v0__fill_2_7 r0 *1 0,0
Xgf180mcu_fd_sc_mcu9t5v0__fill_2_7 VDD VSS gf180mcu_fd_sc_mcu9t5v0__fill_2
* cell instance gf180mcu_fd_sc_mcu9t5v0__fill_2_8 r0 *1 0,0
Xgf180mcu_fd_sc_mcu9t5v0__fill_2_8 VDD VSS gf180mcu_fd_sc_mcu9t5v0__fill_2
* cell instance gf180mcu_fd_sc_mcu9t5v0__fill_2_9 r0 *1 0,0
Xgf180mcu_fd_sc_mcu9t5v0__fill_2_9 VDD VSS gf180mcu_fd_sc_mcu9t5v0__fill_2
* cell instance gf180mcu_fd_sc_mcu9t5v0__fill_2_10 r0 *1 0,0
Xgf180mcu_fd_sc_mcu9t5v0__fill_2_10 VDD VSS gf180mcu_fd_sc_mcu9t5v0__fill_2
* cell instance gf180mcu_fd_sc_mcu9t5v0__fill_2_11 r0 *1 0,0
Xgf180mcu_fd_sc_mcu9t5v0__fill_2_11 VDD VSS gf180mcu_fd_sc_mcu9t5v0__fill_2
* cell instance gf180mcu_fd_sc_mcu9t5v0__fill_2_12 r0 *1 0,0
Xgf180mcu_fd_sc_mcu9t5v0__fill_2_12 VDD VSS gf180mcu_fd_sc_mcu9t5v0__fill_2
* cell instance gf180mcu_fd_sc_mcu9t5v0__fill_2_13 r0 *1 0,0
Xgf180mcu_fd_sc_mcu9t5v0__fill_2_13 VDD VSS gf180mcu_fd_sc_mcu9t5v0__fill_2
* cell instance gf180mcu_fd_sc_mcu9t5v0__fill_2_14 r0 *1 0,0
Xgf180mcu_fd_sc_mcu9t5v0__fill_2_14 VDD VSS gf180mcu_fd_sc_mcu9t5v0__fill_2
* cell instance gf180mcu_fd_sc_mcu9t5v0__fill_2_15 r0 *1 0,0
Xgf180mcu_fd_sc_mcu9t5v0__fill_2_15 VDD VSS gf180mcu_fd_sc_mcu9t5v0__fill_2
* cell instance gf180mcu_fd_sc_mcu9t5v0__fill_2_16 r0 *1 0,0
Xgf180mcu_fd_sc_mcu9t5v0__fill_2_16 VDD VSS gf180mcu_fd_sc_mcu9t5v0__fill_2
* cell instance gf180mcu_fd_sc_mcu9t5v0__fill_2_17 r0 *1 0,0
Xgf180mcu_fd_sc_mcu9t5v0__fill_2_17 VDD VSS gf180mcu_fd_sc_mcu9t5v0__fill_2
* cell instance gf180mcu_fd_sc_mcu9t5v0__fill_2_18 r0 *1 0,0
Xgf180mcu_fd_sc_mcu9t5v0__fill_2_18 VDD VSS gf180mcu_fd_sc_mcu9t5v0__fill_2
* cell instance gf180mcu_fd_sc_mcu9t5v0__fill_2_19 r0 *1 0,0
Xgf180mcu_fd_sc_mcu9t5v0__fill_2_19 VDD VSS gf180mcu_fd_sc_mcu9t5v0__fill_2
* cell instance gf180mcu_fd_sc_mcu9t5v0__fill_2_20 r0 *1 0,0
Xgf180mcu_fd_sc_mcu9t5v0__fill_2_20 VDD VSS gf180mcu_fd_sc_mcu9t5v0__fill_2
* cell instance gf180mcu_fd_sc_mcu9t5v0__fill_2_21 r0 *1 0,0
Xgf180mcu_fd_sc_mcu9t5v0__fill_2_21 VDD VSS gf180mcu_fd_sc_mcu9t5v0__fill_2
* cell instance gf180mcu_fd_sc_mcu9t5v0__fill_2_22 r0 *1 0,0
Xgf180mcu_fd_sc_mcu9t5v0__fill_2_22 VDD VSS gf180mcu_fd_sc_mcu9t5v0__fill_2
* cell instance gf180mcu_fd_sc_mcu9t5v0__fill_2_23 r0 *1 0,0
Xgf180mcu_fd_sc_mcu9t5v0__fill_2_23 VDD VSS gf180mcu_fd_sc_mcu9t5v0__fill_2
* cell instance gf180mcu_fd_sc_mcu9t5v0__fill_2_24 r0 *1 0,0
Xgf180mcu_fd_sc_mcu9t5v0__fill_2_24 VDD VSS gf180mcu_fd_sc_mcu9t5v0__fill_2
* cell instance gf180mcu_fd_sc_mcu9t5v0__fill_2_25 r0 *1 0,0
Xgf180mcu_fd_sc_mcu9t5v0__fill_2_25 VDD VSS gf180mcu_fd_sc_mcu9t5v0__fill_2
* cell instance gf180mcu_fd_sc_mcu9t5v0__fill_2_26 r0 *1 0,0
Xgf180mcu_fd_sc_mcu9t5v0__fill_2_26 VDD VSS gf180mcu_fd_sc_mcu9t5v0__fill_2
* cell instance gf180mcu_fd_sc_mcu9t5v0__fill_2_27 r0 *1 0,0
Xgf180mcu_fd_sc_mcu9t5v0__fill_2_27 VDD VSS gf180mcu_fd_sc_mcu9t5v0__fill_2
* cell instance gf180mcu_fd_sc_mcu9t5v0__fill_2_28 r0 *1 0,0
Xgf180mcu_fd_sc_mcu9t5v0__fill_2_28 VDD VSS gf180mcu_fd_sc_mcu9t5v0__fill_2
* cell instance gf180mcu_fd_sc_mcu9t5v0__fill_2_29 r0 *1 0,0
Xgf180mcu_fd_sc_mcu9t5v0__fill_2_29 VDD VSS gf180mcu_fd_sc_mcu9t5v0__fill_2
* cell instance gf180mcu_fd_sc_mcu9t5v0__fill_2_30 r0 *1 0,0
Xgf180mcu_fd_sc_mcu9t5v0__fill_2_30 VDD VSS gf180mcu_fd_sc_mcu9t5v0__fill_2
* cell instance gf180mcu_fd_sc_mcu9t5v0__fill_2_31 r0 *1 0,0
Xgf180mcu_fd_sc_mcu9t5v0__fill_2_31 VDD VSS gf180mcu_fd_sc_mcu9t5v0__fill_2
* cell instance gf180mcu_fd_sc_mcu9t5v0__fill_2_32 r0 *1 0,0
Xgf180mcu_fd_sc_mcu9t5v0__fill_2_32 VDD VSS gf180mcu_fd_sc_mcu9t5v0__fill_2
* cell instance gf180mcu_fd_sc_mcu9t5v0__fill_2_33 r0 *1 0,0
Xgf180mcu_fd_sc_mcu9t5v0__fill_2_33 VDD VSS gf180mcu_fd_sc_mcu9t5v0__fill_2
* cell instance gf180mcu_fd_sc_mcu9t5v0__fill_2_34 r0 *1 0,0
Xgf180mcu_fd_sc_mcu9t5v0__fill_2_34 VDD VSS gf180mcu_fd_sc_mcu9t5v0__fill_2
* cell instance gf180mcu_fd_sc_mcu9t5v0__fill_2_35 r0 *1 0,0
Xgf180mcu_fd_sc_mcu9t5v0__fill_2_35 VDD VSS gf180mcu_fd_sc_mcu9t5v0__fill_2
* cell instance gf180mcu_fd_sc_mcu9t5v0__fill_2_36 r0 *1 0,0
Xgf180mcu_fd_sc_mcu9t5v0__fill_2_36 VDD VSS gf180mcu_fd_sc_mcu9t5v0__fill_2
* cell instance gf180mcu_fd_sc_mcu9t5v0__fill_2_37 r0 *1 0,0
Xgf180mcu_fd_sc_mcu9t5v0__fill_2_37 VDD VSS gf180mcu_fd_sc_mcu9t5v0__fill_2
* cell instance gf180mcu_fd_sc_mcu9t5v0__fill_2_38 r0 *1 0,0
Xgf180mcu_fd_sc_mcu9t5v0__fill_2_38 VDD VSS gf180mcu_fd_sc_mcu9t5v0__fill_2
* cell instance gf180mcu_fd_sc_mcu9t5v0__fill_2_39 r0 *1 0,0
Xgf180mcu_fd_sc_mcu9t5v0__fill_2_39 VDD VSS gf180mcu_fd_sc_mcu9t5v0__fill_2
* cell instance gf180mcu_fd_sc_mcu9t5v0__fill_2_40 r0 *1 0,0
Xgf180mcu_fd_sc_mcu9t5v0__fill_2_40 VDD VSS gf180mcu_fd_sc_mcu9t5v0__fill_2
* cell instance gf180mcu_fd_sc_mcu9t5v0__fill_2_41 r0 *1 0,0
Xgf180mcu_fd_sc_mcu9t5v0__fill_2_41 VDD VSS gf180mcu_fd_sc_mcu9t5v0__fill_2
* cell instance gf180mcu_fd_sc_mcu9t5v0__fill_2_42 r0 *1 0,0
Xgf180mcu_fd_sc_mcu9t5v0__fill_2_42 VDD VSS gf180mcu_fd_sc_mcu9t5v0__fill_2
* cell instance gf180mcu_fd_sc_mcu9t5v0__fill_2_43 r0 *1 0,0
Xgf180mcu_fd_sc_mcu9t5v0__fill_2_43 VDD VSS gf180mcu_fd_sc_mcu9t5v0__fill_2
* cell instance gf180mcu_fd_sc_mcu9t5v0__fill_2_44 r0 *1 0,0
Xgf180mcu_fd_sc_mcu9t5v0__fill_2_44 VDD VSS gf180mcu_fd_sc_mcu9t5v0__fill_2
* cell instance gf180mcu_fd_sc_mcu9t5v0__fill_2_45 r0 *1 0,0
Xgf180mcu_fd_sc_mcu9t5v0__fill_2_45 VDD VSS gf180mcu_fd_sc_mcu9t5v0__fill_2
* cell instance gf180mcu_fd_sc_mcu9t5v0__fill_2_46 r0 *1 0,0
Xgf180mcu_fd_sc_mcu9t5v0__fill_2_46 VDD VSS gf180mcu_fd_sc_mcu9t5v0__fill_2
* cell instance gf180mcu_fd_sc_mcu9t5v0__fill_2_47 r0 *1 0,0
Xgf180mcu_fd_sc_mcu9t5v0__fill_2_47 VDD VSS gf180mcu_fd_sc_mcu9t5v0__fill_2
* cell instance gf180mcu_fd_sc_mcu9t5v0__fill_2_48 r0 *1 0,0
Xgf180mcu_fd_sc_mcu9t5v0__fill_2_48 VDD VSS gf180mcu_fd_sc_mcu9t5v0__fill_2
* cell instance gf180mcu_fd_sc_mcu9t5v0__fill_2_49 r0 *1 0,0
Xgf180mcu_fd_sc_mcu9t5v0__fill_2_49 VDD VSS gf180mcu_fd_sc_mcu9t5v0__fill_2
* cell instance gf180mcu_fd_sc_mcu9t5v0__fill_2_50 r0 *1 0,0
Xgf180mcu_fd_sc_mcu9t5v0__fill_2_50 VDD VSS gf180mcu_fd_sc_mcu9t5v0__fill_2
* cell instance gf180mcu_fd_sc_mcu9t5v0__fill_2_51 r0 *1 0,0
Xgf180mcu_fd_sc_mcu9t5v0__fill_2_51 VDD VSS gf180mcu_fd_sc_mcu9t5v0__fill_2
* cell instance gf180mcu_fd_sc_mcu9t5v0__fill_2_52 r0 *1 0,0
Xgf180mcu_fd_sc_mcu9t5v0__fill_2_52 VDD VSS gf180mcu_fd_sc_mcu9t5v0__fill_2
* cell instance gf180mcu_fd_sc_mcu9t5v0__fill_2_53 r0 *1 0,0
Xgf180mcu_fd_sc_mcu9t5v0__fill_2_53 VDD VSS gf180mcu_fd_sc_mcu9t5v0__fill_2
* cell instance gf180mcu_fd_sc_mcu9t5v0__fill_2_54 r0 *1 0,0
Xgf180mcu_fd_sc_mcu9t5v0__fill_2_54 VDD VSS gf180mcu_fd_sc_mcu9t5v0__fill_2
* cell instance gf180mcu_fd_sc_mcu9t5v0__fill_2_55 r0 *1 0,0
Xgf180mcu_fd_sc_mcu9t5v0__fill_2_55 VDD VSS gf180mcu_fd_sc_mcu9t5v0__fill_2
* cell instance gf180mcu_fd_sc_mcu9t5v0__fill_2_56 r0 *1 0,0
Xgf180mcu_fd_sc_mcu9t5v0__fill_2_56 VDD VSS gf180mcu_fd_sc_mcu9t5v0__fill_2
* cell instance gf180mcu_fd_sc_mcu9t5v0__fill_2_57 r0 *1 0,0
Xgf180mcu_fd_sc_mcu9t5v0__fill_2_57 VDD VSS gf180mcu_fd_sc_mcu9t5v0__fill_2
* cell instance gf180mcu_fd_sc_mcu9t5v0__fill_2_58 r0 *1 0,0
Xgf180mcu_fd_sc_mcu9t5v0__fill_2_58 VDD VSS gf180mcu_fd_sc_mcu9t5v0__fill_2
* cell instance gf180mcu_fd_sc_mcu9t5v0__fill_2_59 r0 *1 0,0
Xgf180mcu_fd_sc_mcu9t5v0__fill_2_59 VDD VSS gf180mcu_fd_sc_mcu9t5v0__fill_2
* cell instance gf180mcu_fd_sc_mcu9t5v0__fill_2_60 r0 *1 0,0
Xgf180mcu_fd_sc_mcu9t5v0__fill_2_60 VDD VSS gf180mcu_fd_sc_mcu9t5v0__fill_2
* cell instance gf180mcu_fd_sc_mcu9t5v0__fill_2_61 r0 *1 0,0
Xgf180mcu_fd_sc_mcu9t5v0__fill_2_61 VDD VSS gf180mcu_fd_sc_mcu9t5v0__fill_2
* cell instance gf180mcu_fd_sc_mcu9t5v0__fill_2_62 r0 *1 0,0
Xgf180mcu_fd_sc_mcu9t5v0__fill_2_62 VDD VSS gf180mcu_fd_sc_mcu9t5v0__fill_2
* cell instance gf180mcu_fd_sc_mcu9t5v0__fill_2_63 r0 *1 0,0
Xgf180mcu_fd_sc_mcu9t5v0__fill_2_63 VDD VSS gf180mcu_fd_sc_mcu9t5v0__fill_2
* cell instance gf180mcu_fd_sc_mcu9t5v0__fill_2_64 r0 *1 0,0
Xgf180mcu_fd_sc_mcu9t5v0__fill_2_64 VDD VSS gf180mcu_fd_sc_mcu9t5v0__fill_2
* cell instance gf180mcu_fd_sc_mcu9t5v0__fill_2_65 r0 *1 0,0
Xgf180mcu_fd_sc_mcu9t5v0__fill_2_65 VDD VSS gf180mcu_fd_sc_mcu9t5v0__fill_2
* cell instance gf180mcu_fd_sc_mcu9t5v0__fill_2_66 r0 *1 0,0
Xgf180mcu_fd_sc_mcu9t5v0__fill_2_66 VDD VSS gf180mcu_fd_sc_mcu9t5v0__fill_2
* cell instance gf180mcu_fd_sc_mcu9t5v0__fill_2_67 r0 *1 0,0
Xgf180mcu_fd_sc_mcu9t5v0__fill_2_67 VDD VSS gf180mcu_fd_sc_mcu9t5v0__fill_2
* cell instance gf180mcu_fd_sc_mcu9t5v0__fill_2_68 r0 *1 0,0
Xgf180mcu_fd_sc_mcu9t5v0__fill_2_68 VDD VSS gf180mcu_fd_sc_mcu9t5v0__fill_2
* cell instance gf180mcu_fd_sc_mcu9t5v0__fill_2_69 r0 *1 0,0
Xgf180mcu_fd_sc_mcu9t5v0__fill_2_69 VDD VSS gf180mcu_fd_sc_mcu9t5v0__fill_2
* cell instance gf180mcu_fd_sc_mcu9t5v0__fill_2_70 r0 *1 0,0
Xgf180mcu_fd_sc_mcu9t5v0__fill_2_70 VDD VSS gf180mcu_fd_sc_mcu9t5v0__fill_2
* cell instance gf180mcu_fd_sc_mcu9t5v0__fill_2_71 r0 *1 0,0
Xgf180mcu_fd_sc_mcu9t5v0__fill_2_71 VDD VSS gf180mcu_fd_sc_mcu9t5v0__fill_2
* cell instance gf180mcu_fd_sc_mcu9t5v0__fill_2_72 r0 *1 0,0
Xgf180mcu_fd_sc_mcu9t5v0__fill_2_72 VDD VSS gf180mcu_fd_sc_mcu9t5v0__fill_2
* cell instance gf180mcu_fd_sc_mcu9t5v0__fill_2_73 r0 *1 0,0
Xgf180mcu_fd_sc_mcu9t5v0__fill_2_73 VDD VSS gf180mcu_fd_sc_mcu9t5v0__fill_2
* cell instance gf180mcu_fd_sc_mcu9t5v0__fill_2_74 r0 *1 0,0
Xgf180mcu_fd_sc_mcu9t5v0__fill_2_74 VDD VSS gf180mcu_fd_sc_mcu9t5v0__fill_2
* cell instance gf180mcu_fd_sc_mcu9t5v0__fill_2_75 r0 *1 0,0
Xgf180mcu_fd_sc_mcu9t5v0__fill_2_75 VDD VSS gf180mcu_fd_sc_mcu9t5v0__fill_2
* cell instance gf180mcu_fd_sc_mcu9t5v0__fill_2_76 r0 *1 0,0
Xgf180mcu_fd_sc_mcu9t5v0__fill_2_76 VDD VSS gf180mcu_fd_sc_mcu9t5v0__fill_2
* cell instance gf180mcu_fd_sc_mcu9t5v0__fill_2_77 r0 *1 0,0
Xgf180mcu_fd_sc_mcu9t5v0__fill_2_77 VDD VSS gf180mcu_fd_sc_mcu9t5v0__fill_2
* cell instance gf180mcu_fd_sc_mcu9t5v0__fill_2_78 r0 *1 0,0
Xgf180mcu_fd_sc_mcu9t5v0__fill_2_78 VDD VSS gf180mcu_fd_sc_mcu9t5v0__fill_2
* cell instance gf180mcu_fd_sc_mcu9t5v0__fill_2_79 r0 *1 0,0
Xgf180mcu_fd_sc_mcu9t5v0__fill_2_79 VDD VSS gf180mcu_fd_sc_mcu9t5v0__fill_2
* cell instance gf180mcu_fd_sc_mcu9t5v0__fill_2_80 r0 *1 0,0
Xgf180mcu_fd_sc_mcu9t5v0__fill_2_80 VDD VSS gf180mcu_fd_sc_mcu9t5v0__fill_2
* cell instance gf180mcu_fd_sc_mcu9t5v0__fill_2_81 r0 *1 0,0
Xgf180mcu_fd_sc_mcu9t5v0__fill_2_81 VDD VSS gf180mcu_fd_sc_mcu9t5v0__fill_2
* cell instance gf180mcu_fd_sc_mcu9t5v0__fill_2_82 r0 *1 0,0
Xgf180mcu_fd_sc_mcu9t5v0__fill_2_82 VDD VSS gf180mcu_fd_sc_mcu9t5v0__fill_2
* cell instance gf180mcu_fd_sc_mcu9t5v0__fill_2_83 r0 *1 0,0
Xgf180mcu_fd_sc_mcu9t5v0__fill_2_83 VDD VSS gf180mcu_fd_sc_mcu9t5v0__fill_2
* cell instance gf180mcu_fd_sc_mcu9t5v0__fill_2_84 r0 *1 0,0
Xgf180mcu_fd_sc_mcu9t5v0__fill_2_84 VDD VSS gf180mcu_fd_sc_mcu9t5v0__fill_2
* cell instance gf180mcu_fd_sc_mcu9t5v0__fill_2_85 r0 *1 0,0
Xgf180mcu_fd_sc_mcu9t5v0__fill_2_85 VDD VSS gf180mcu_fd_sc_mcu9t5v0__fill_2
* cell instance gf180mcu_fd_sc_mcu9t5v0__fill_2_86 r0 *1 0,0
Xgf180mcu_fd_sc_mcu9t5v0__fill_2_86 VDD VSS gf180mcu_fd_sc_mcu9t5v0__fill_2
* cell instance gf180mcu_fd_sc_mcu9t5v0__fill_2_87 r0 *1 0,0
Xgf180mcu_fd_sc_mcu9t5v0__fill_2_87 VDD VSS gf180mcu_fd_sc_mcu9t5v0__fill_2
* cell instance gf180mcu_fd_sc_mcu9t5v0__fill_2_88 r0 *1 0,0
Xgf180mcu_fd_sc_mcu9t5v0__fill_2_88 VDD VSS gf180mcu_fd_sc_mcu9t5v0__fill_2
* cell instance gf180mcu_fd_sc_mcu9t5v0__fill_2_89 r0 *1 0,0
Xgf180mcu_fd_sc_mcu9t5v0__fill_2_89 VDD VSS gf180mcu_fd_sc_mcu9t5v0__fill_2
* cell instance gf180mcu_fd_sc_mcu9t5v0__fill_2_90 r0 *1 0,0
Xgf180mcu_fd_sc_mcu9t5v0__fill_2_90 VDD VSS gf180mcu_fd_sc_mcu9t5v0__fill_2
* cell instance gf180mcu_fd_sc_mcu9t5v0__fill_2_91 r0 *1 0,0
Xgf180mcu_fd_sc_mcu9t5v0__fill_2_91 VDD VSS gf180mcu_fd_sc_mcu9t5v0__fill_2
* cell instance gf180mcu_fd_sc_mcu9t5v0__fill_2_92 r0 *1 0,0
Xgf180mcu_fd_sc_mcu9t5v0__fill_2_92 VDD VSS gf180mcu_fd_sc_mcu9t5v0__fill_2
* cell instance gf180mcu_fd_sc_mcu9t5v0__fill_2_93 r0 *1 0,0
Xgf180mcu_fd_sc_mcu9t5v0__fill_2_93 VDD VSS gf180mcu_fd_sc_mcu9t5v0__fill_2
* cell instance gf180mcu_fd_sc_mcu9t5v0__fill_2_94 r0 *1 0,0
Xgf180mcu_fd_sc_mcu9t5v0__fill_2_94 VDD VSS gf180mcu_fd_sc_mcu9t5v0__fill_2
* cell instance gf180mcu_fd_sc_mcu9t5v0__fill_2_95 r0 *1 0,0
Xgf180mcu_fd_sc_mcu9t5v0__fill_2_95 VDD VSS gf180mcu_fd_sc_mcu9t5v0__fill_2
* cell instance gf180mcu_fd_sc_mcu9t5v0__fill_2_96 r0 *1 0,0
Xgf180mcu_fd_sc_mcu9t5v0__fill_2_96 VDD VSS gf180mcu_fd_sc_mcu9t5v0__fill_2
* cell instance gf180mcu_fd_sc_mcu9t5v0__fill_2_97 r0 *1 0,0
Xgf180mcu_fd_sc_mcu9t5v0__fill_2_97 VDD VSS gf180mcu_fd_sc_mcu9t5v0__fill_2
* cell instance gf180mcu_fd_sc_mcu9t5v0__fill_2_98 r0 *1 0,0
Xgf180mcu_fd_sc_mcu9t5v0__fill_2_98 VDD VSS gf180mcu_fd_sc_mcu9t5v0__fill_2
* cell instance gf180mcu_fd_sc_mcu9t5v0__fill_2_99 r0 *1 0,0
Xgf180mcu_fd_sc_mcu9t5v0__fill_2_99 VDD VSS gf180mcu_fd_sc_mcu9t5v0__fill_2
* cell instance gf180mcu_fd_sc_mcu9t5v0__fill_2_100 r0 *1 0,0
Xgf180mcu_fd_sc_mcu9t5v0__fill_2_100 VDD VSS gf180mcu_fd_sc_mcu9t5v0__fill_2
* cell instance gf180mcu_fd_sc_mcu9t5v0__fill_2_101 r0 *1 0,0
Xgf180mcu_fd_sc_mcu9t5v0__fill_2_101 VDD VSS gf180mcu_fd_sc_mcu9t5v0__fill_2
* cell instance gf180mcu_fd_sc_mcu9t5v0__fill_2_102 r0 *1 0,0
Xgf180mcu_fd_sc_mcu9t5v0__fill_2_102 VDD VSS gf180mcu_fd_sc_mcu9t5v0__fill_2
* cell instance gf180mcu_fd_sc_mcu9t5v0__fill_2_103 r0 *1 0,0
Xgf180mcu_fd_sc_mcu9t5v0__fill_2_103 VDD VSS gf180mcu_fd_sc_mcu9t5v0__fill_2
* cell instance gf180mcu_fd_sc_mcu9t5v0__fill_2_104 r0 *1 0,0
Xgf180mcu_fd_sc_mcu9t5v0__fill_2_104 VDD VSS gf180mcu_fd_sc_mcu9t5v0__fill_2
* cell instance gf180mcu_fd_sc_mcu9t5v0__fill_2_105 r0 *1 0,0
Xgf180mcu_fd_sc_mcu9t5v0__fill_2_105 VDD VSS gf180mcu_fd_sc_mcu9t5v0__fill_2
* cell instance gf180mcu_fd_sc_mcu9t5v0__fill_2_106 r0 *1 0,0
Xgf180mcu_fd_sc_mcu9t5v0__fill_2_106 VDD VSS gf180mcu_fd_sc_mcu9t5v0__fill_2
* cell instance gf180mcu_fd_sc_mcu9t5v0__fill_2_107 r0 *1 0,0
Xgf180mcu_fd_sc_mcu9t5v0__fill_2_107 VDD VSS gf180mcu_fd_sc_mcu9t5v0__fill_2
* cell instance gf180mcu_fd_sc_mcu9t5v0__fill_2_108 r0 *1 0,0
Xgf180mcu_fd_sc_mcu9t5v0__fill_2_108 VDD VSS gf180mcu_fd_sc_mcu9t5v0__fill_2
* cell instance gf180mcu_fd_sc_mcu9t5v0__fill_2_109 r0 *1 0,0
Xgf180mcu_fd_sc_mcu9t5v0__fill_2_109 VDD VSS gf180mcu_fd_sc_mcu9t5v0__fill_2
* cell instance gf180mcu_fd_sc_mcu9t5v0__fill_2_110 r0 *1 0,0
Xgf180mcu_fd_sc_mcu9t5v0__fill_2_110 VDD VSS gf180mcu_fd_sc_mcu9t5v0__fill_2
* cell instance gf180mcu_fd_sc_mcu9t5v0__fill_2_111 r0 *1 0,0
Xgf180mcu_fd_sc_mcu9t5v0__fill_2_111 VDD VSS gf180mcu_fd_sc_mcu9t5v0__fill_2
* cell instance gf180mcu_fd_sc_mcu9t5v0__fill_2_112 r0 *1 0,0
Xgf180mcu_fd_sc_mcu9t5v0__fill_2_112 VDD VSS gf180mcu_fd_sc_mcu9t5v0__fill_2
* cell instance gf180mcu_fd_sc_mcu9t5v0__fill_2_113 r0 *1 0,0
Xgf180mcu_fd_sc_mcu9t5v0__fill_2_113 VDD VSS gf180mcu_fd_sc_mcu9t5v0__fill_2
* cell instance gf180mcu_fd_sc_mcu9t5v0__fill_2_114 r0 *1 0,0
Xgf180mcu_fd_sc_mcu9t5v0__fill_2_114 VDD VSS gf180mcu_fd_sc_mcu9t5v0__fill_2
* cell instance gf180mcu_fd_sc_mcu9t5v0__fill_2_115 r0 *1 0,0
Xgf180mcu_fd_sc_mcu9t5v0__fill_2_115 VDD VSS gf180mcu_fd_sc_mcu9t5v0__fill_2
* cell instance gf180mcu_fd_sc_mcu9t5v0__fill_2_116 r0 *1 0,0
Xgf180mcu_fd_sc_mcu9t5v0__fill_2_116 VDD VSS gf180mcu_fd_sc_mcu9t5v0__fill_2
* cell instance gf180mcu_fd_sc_mcu9t5v0__fill_2_117 r0 *1 0,0
Xgf180mcu_fd_sc_mcu9t5v0__fill_2_117 VDD VSS gf180mcu_fd_sc_mcu9t5v0__fill_2
* cell instance gf180mcu_fd_sc_mcu9t5v0__fill_2_118 r0 *1 0,0
Xgf180mcu_fd_sc_mcu9t5v0__fill_2_118 VDD VSS gf180mcu_fd_sc_mcu9t5v0__fill_2
* cell instance gf180mcu_fd_sc_mcu9t5v0__fill_2_119 r0 *1 0,0
Xgf180mcu_fd_sc_mcu9t5v0__fill_2_119 VDD VSS gf180mcu_fd_sc_mcu9t5v0__fill_2
* cell instance gf180mcu_fd_sc_mcu9t5v0__fill_2_120 r0 *1 0,0
Xgf180mcu_fd_sc_mcu9t5v0__fill_2_120 VDD VSS gf180mcu_fd_sc_mcu9t5v0__fill_2
* cell instance gf180mcu_fd_sc_mcu9t5v0__fill_2_121 r0 *1 0,0
Xgf180mcu_fd_sc_mcu9t5v0__fill_2_121 VDD VSS gf180mcu_fd_sc_mcu9t5v0__fill_2
* cell instance gf180mcu_fd_sc_mcu9t5v0__fill_2_122 r0 *1 0,0
Xgf180mcu_fd_sc_mcu9t5v0__fill_2_122 VDD VSS gf180mcu_fd_sc_mcu9t5v0__fill_2
* cell instance gf180mcu_fd_sc_mcu9t5v0__fill_2_123 r0 *1 0,0
Xgf180mcu_fd_sc_mcu9t5v0__fill_2_123 VDD VSS gf180mcu_fd_sc_mcu9t5v0__fill_2
* cell instance gf180mcu_fd_sc_mcu9t5v0__fill_2_124 r0 *1 0,0
Xgf180mcu_fd_sc_mcu9t5v0__fill_2_124 VDD VSS gf180mcu_fd_sc_mcu9t5v0__fill_2
* cell instance gf180mcu_fd_sc_mcu9t5v0__fill_2_125 r0 *1 0,0
Xgf180mcu_fd_sc_mcu9t5v0__fill_2_125 VDD VSS gf180mcu_fd_sc_mcu9t5v0__fill_2
* cell instance gf180mcu_fd_sc_mcu9t5v0__fill_2_126 r0 *1 0,0
Xgf180mcu_fd_sc_mcu9t5v0__fill_2_126 VDD VSS gf180mcu_fd_sc_mcu9t5v0__fill_2
* cell instance gf180mcu_fd_sc_mcu9t5v0__fill_2_127 r0 *1 0,0
Xgf180mcu_fd_sc_mcu9t5v0__fill_2_127 VDD VSS gf180mcu_fd_sc_mcu9t5v0__fill_2
* cell instance gf180mcu_fd_sc_mcu9t5v0__fill_2_128 r0 *1 0,0
Xgf180mcu_fd_sc_mcu9t5v0__fill_2_128 VDD VSS gf180mcu_fd_sc_mcu9t5v0__fill_2
* cell instance gf180mcu_fd_sc_mcu9t5v0__fill_2_129 r0 *1 0,0
Xgf180mcu_fd_sc_mcu9t5v0__fill_2_129 VDD VSS gf180mcu_fd_sc_mcu9t5v0__fill_2
* cell instance gf180mcu_fd_sc_mcu9t5v0__fill_2_130 r0 *1 0,0
Xgf180mcu_fd_sc_mcu9t5v0__fill_2_130 VDD VSS gf180mcu_fd_sc_mcu9t5v0__fill_2
* cell instance gf180mcu_fd_sc_mcu9t5v0__fill_2_131 r0 *1 0,0
Xgf180mcu_fd_sc_mcu9t5v0__fill_2_131 VDD VSS gf180mcu_fd_sc_mcu9t5v0__fill_2
* cell instance gf180mcu_fd_sc_mcu9t5v0__fill_2_132 r0 *1 0,0
Xgf180mcu_fd_sc_mcu9t5v0__fill_2_132 VDD VSS gf180mcu_fd_sc_mcu9t5v0__fill_2
* cell instance gf180mcu_fd_sc_mcu9t5v0__fill_2_133 r0 *1 0,0
Xgf180mcu_fd_sc_mcu9t5v0__fill_2_133 VDD VSS gf180mcu_fd_sc_mcu9t5v0__fill_2
* cell instance gf180mcu_fd_sc_mcu9t5v0__fill_2_134 r0 *1 0,0
Xgf180mcu_fd_sc_mcu9t5v0__fill_2_134 VDD VSS gf180mcu_fd_sc_mcu9t5v0__fill_2
* cell instance gf180mcu_fd_sc_mcu9t5v0__fill_2_135 r0 *1 0,0
Xgf180mcu_fd_sc_mcu9t5v0__fill_2_135 VDD VSS gf180mcu_fd_sc_mcu9t5v0__fill_2
* cell instance gf180mcu_fd_sc_mcu9t5v0__fill_2_136 r0 *1 0,0
Xgf180mcu_fd_sc_mcu9t5v0__fill_2_136 VDD VSS gf180mcu_fd_sc_mcu9t5v0__fill_2
* cell instance gf180mcu_fd_sc_mcu9t5v0__fill_2_137 r0 *1 0,0
Xgf180mcu_fd_sc_mcu9t5v0__fill_2_137 VDD VSS gf180mcu_fd_sc_mcu9t5v0__fill_2
* cell instance gf180mcu_fd_sc_mcu9t5v0__fill_2_138 r0 *1 0,0
Xgf180mcu_fd_sc_mcu9t5v0__fill_2_138 VDD VSS gf180mcu_fd_sc_mcu9t5v0__fill_2
* cell instance gf180mcu_fd_sc_mcu9t5v0__fill_2_139 r0 *1 0,0
Xgf180mcu_fd_sc_mcu9t5v0__fill_2_139 VDD VSS gf180mcu_fd_sc_mcu9t5v0__fill_2
* cell instance gf180mcu_fd_sc_mcu9t5v0__fill_2_140 r0 *1 0,0
Xgf180mcu_fd_sc_mcu9t5v0__fill_2_140 VDD VSS gf180mcu_fd_sc_mcu9t5v0__fill_2
* cell instance gf180mcu_fd_sc_mcu9t5v0__fill_2_141 r0 *1 0,0
Xgf180mcu_fd_sc_mcu9t5v0__fill_2_141 VDD VSS gf180mcu_fd_sc_mcu9t5v0__fill_2
* cell instance gf180mcu_fd_sc_mcu9t5v0__fill_2_142 r0 *1 0,0
Xgf180mcu_fd_sc_mcu9t5v0__fill_2_142 VDD VSS gf180mcu_fd_sc_mcu9t5v0__fill_2
* cell instance gf180mcu_fd_sc_mcu9t5v0__fill_2_143 r0 *1 0,0
Xgf180mcu_fd_sc_mcu9t5v0__fill_2_143 VDD VSS gf180mcu_fd_sc_mcu9t5v0__fill_2
* cell instance gf180mcu_fd_sc_mcu9t5v0__fill_2_144 r0 *1 0,0
Xgf180mcu_fd_sc_mcu9t5v0__fill_2_144 VDD VSS gf180mcu_fd_sc_mcu9t5v0__fill_2
* cell instance gf180mcu_fd_sc_mcu9t5v0__fill_2_145 r0 *1 0,0
Xgf180mcu_fd_sc_mcu9t5v0__fill_2_145 VDD VSS gf180mcu_fd_sc_mcu9t5v0__fill_2
* cell instance gf180mcu_fd_sc_mcu9t5v0__fill_2_146 r0 *1 0,0
Xgf180mcu_fd_sc_mcu9t5v0__fill_2_146 VDD VSS gf180mcu_fd_sc_mcu9t5v0__fill_2
* cell instance gf180mcu_fd_sc_mcu9t5v0__fill_2_147 r0 *1 0,0
Xgf180mcu_fd_sc_mcu9t5v0__fill_2_147 VDD VSS gf180mcu_fd_sc_mcu9t5v0__fill_2
* cell instance gf180mcu_fd_sc_mcu9t5v0__fill_2_148 r0 *1 0,0
Xgf180mcu_fd_sc_mcu9t5v0__fill_2_148 VDD VSS gf180mcu_fd_sc_mcu9t5v0__fill_2
* cell instance gf180mcu_fd_sc_mcu9t5v0__fill_2_149 r0 *1 0,0
Xgf180mcu_fd_sc_mcu9t5v0__fill_2_149 VDD VSS gf180mcu_fd_sc_mcu9t5v0__fill_2
* cell instance gf180mcu_fd_sc_mcu9t5v0__fill_2_150 r0 *1 0,0
Xgf180mcu_fd_sc_mcu9t5v0__fill_2_150 VDD VSS gf180mcu_fd_sc_mcu9t5v0__fill_2
* cell instance gf180mcu_fd_sc_mcu9t5v0__fill_32_0 r0 *1 0,0
Xgf180mcu_fd_sc_mcu9t5v0__fill_32_0 VDD VSS gf180mcu_fd_sc_mcu9t5v0__fill_32
* cell instance gf180mcu_fd_sc_mcu9t5v0__fill_32_1 r0 *1 0,0
Xgf180mcu_fd_sc_mcu9t5v0__fill_32_1 VDD VSS gf180mcu_fd_sc_mcu9t5v0__fill_32
* cell instance gf180mcu_fd_sc_mcu9t5v0__fill_32_2 r0 *1 0,0
Xgf180mcu_fd_sc_mcu9t5v0__fill_32_2 VDD VSS gf180mcu_fd_sc_mcu9t5v0__fill_32
* cell instance gf180mcu_fd_sc_mcu9t5v0__fill_32_3 r0 *1 0,0
Xgf180mcu_fd_sc_mcu9t5v0__fill_32_3 VDD VSS gf180mcu_fd_sc_mcu9t5v0__fill_32
* cell instance gf180mcu_fd_sc_mcu9t5v0__fill_32_4 r0 *1 0,0
Xgf180mcu_fd_sc_mcu9t5v0__fill_32_4 VDD VSS gf180mcu_fd_sc_mcu9t5v0__fill_32
* cell instance gf180mcu_fd_sc_mcu9t5v0__fill_32_5 r0 *1 0,0
Xgf180mcu_fd_sc_mcu9t5v0__fill_32_5 VDD VSS gf180mcu_fd_sc_mcu9t5v0__fill_32
* cell instance gf180mcu_fd_sc_mcu9t5v0__fill_32_6 r0 *1 0,0
Xgf180mcu_fd_sc_mcu9t5v0__fill_32_6 VDD VSS gf180mcu_fd_sc_mcu9t5v0__fill_32
* cell instance gf180mcu_fd_sc_mcu9t5v0__fill_32_7 r0 *1 0,0
Xgf180mcu_fd_sc_mcu9t5v0__fill_32_7 VDD VSS gf180mcu_fd_sc_mcu9t5v0__fill_32
* cell instance gf180mcu_fd_sc_mcu9t5v0__fill_32_8 r0 *1 0,0
Xgf180mcu_fd_sc_mcu9t5v0__fill_32_8 VDD VSS gf180mcu_fd_sc_mcu9t5v0__fill_32
* cell instance gf180mcu_fd_sc_mcu9t5v0__fill_32_9 r0 *1 0,0
Xgf180mcu_fd_sc_mcu9t5v0__fill_32_9 VDD VSS gf180mcu_fd_sc_mcu9t5v0__fill_32
* cell instance gf180mcu_fd_sc_mcu9t5v0__fill_32_10 r0 *1 0,0
Xgf180mcu_fd_sc_mcu9t5v0__fill_32_10 VDD VSS gf180mcu_fd_sc_mcu9t5v0__fill_32
* cell instance gf180mcu_fd_sc_mcu9t5v0__fill_32_11 r0 *1 0,0
Xgf180mcu_fd_sc_mcu9t5v0__fill_32_11 VDD VSS gf180mcu_fd_sc_mcu9t5v0__fill_32
* cell instance gf180mcu_fd_sc_mcu9t5v0__fill_32_12 r0 *1 0,0
Xgf180mcu_fd_sc_mcu9t5v0__fill_32_12 VDD VSS gf180mcu_fd_sc_mcu9t5v0__fill_32
* cell instance gf180mcu_fd_sc_mcu9t5v0__fill_32_13 r0 *1 0,0
Xgf180mcu_fd_sc_mcu9t5v0__fill_32_13 VDD VSS gf180mcu_fd_sc_mcu9t5v0__fill_32
* cell instance gf180mcu_fd_sc_mcu9t5v0__fill_32_14 r0 *1 0,0
Xgf180mcu_fd_sc_mcu9t5v0__fill_32_14 VDD VSS gf180mcu_fd_sc_mcu9t5v0__fill_32
* cell instance gf180mcu_fd_sc_mcu9t5v0__fill_32_15 r0 *1 0,0
Xgf180mcu_fd_sc_mcu9t5v0__fill_32_15 VDD VSS gf180mcu_fd_sc_mcu9t5v0__fill_32
* cell instance gf180mcu_fd_sc_mcu9t5v0__fill_32_16 r0 *1 0,0
Xgf180mcu_fd_sc_mcu9t5v0__fill_32_16 VDD VSS gf180mcu_fd_sc_mcu9t5v0__fill_32
* cell instance gf180mcu_fd_sc_mcu9t5v0__fill_32_17 r0 *1 0,0
Xgf180mcu_fd_sc_mcu9t5v0__fill_32_17 VDD VSS gf180mcu_fd_sc_mcu9t5v0__fill_32
* cell instance gf180mcu_fd_sc_mcu9t5v0__fill_32_18 r0 *1 0,0
Xgf180mcu_fd_sc_mcu9t5v0__fill_32_18 VDD VSS gf180mcu_fd_sc_mcu9t5v0__fill_32
* cell instance gf180mcu_fd_sc_mcu9t5v0__fill_32_19 r0 *1 0,0
Xgf180mcu_fd_sc_mcu9t5v0__fill_32_19 VDD VSS gf180mcu_fd_sc_mcu9t5v0__fill_32
* cell instance gf180mcu_fd_sc_mcu9t5v0__fill_32_20 r0 *1 0,0
Xgf180mcu_fd_sc_mcu9t5v0__fill_32_20 VDD VSS gf180mcu_fd_sc_mcu9t5v0__fill_32
* cell instance gf180mcu_fd_sc_mcu9t5v0__fill_32_21 r0 *1 0,0
Xgf180mcu_fd_sc_mcu9t5v0__fill_32_21 VDD VSS gf180mcu_fd_sc_mcu9t5v0__fill_32
* cell instance gf180mcu_fd_sc_mcu9t5v0__fill_32_22 r0 *1 0,0
Xgf180mcu_fd_sc_mcu9t5v0__fill_32_22 VDD VSS gf180mcu_fd_sc_mcu9t5v0__fill_32
* cell instance gf180mcu_fd_sc_mcu9t5v0__fill_32_23 r0 *1 0,0
Xgf180mcu_fd_sc_mcu9t5v0__fill_32_23 VDD VSS gf180mcu_fd_sc_mcu9t5v0__fill_32
* cell instance gf180mcu_fd_sc_mcu9t5v0__fill_32_24 r0 *1 0,0
Xgf180mcu_fd_sc_mcu9t5v0__fill_32_24 VDD VSS gf180mcu_fd_sc_mcu9t5v0__fill_32
* cell instance gf180mcu_fd_sc_mcu9t5v0__fill_4_0 r0 *1 0,0
Xgf180mcu_fd_sc_mcu9t5v0__fill_4_0 VDD VSS gf180mcu_fd_sc_mcu9t5v0__fill_4
* cell instance gf180mcu_fd_sc_mcu9t5v0__fill_4_1 r0 *1 0,0
Xgf180mcu_fd_sc_mcu9t5v0__fill_4_1 VDD VSS gf180mcu_fd_sc_mcu9t5v0__fill_4
* cell instance gf180mcu_fd_sc_mcu9t5v0__fill_4_2 r0 *1 0,0
Xgf180mcu_fd_sc_mcu9t5v0__fill_4_2 VDD VSS gf180mcu_fd_sc_mcu9t5v0__fill_4
* cell instance gf180mcu_fd_sc_mcu9t5v0__fill_4_3 r0 *1 0,0
Xgf180mcu_fd_sc_mcu9t5v0__fill_4_3 VDD VSS gf180mcu_fd_sc_mcu9t5v0__fill_4
* cell instance gf180mcu_fd_sc_mcu9t5v0__fill_4_4 r0 *1 0,0
Xgf180mcu_fd_sc_mcu9t5v0__fill_4_4 VDD VSS gf180mcu_fd_sc_mcu9t5v0__fill_4
* cell instance gf180mcu_fd_sc_mcu9t5v0__fill_4_5 r0 *1 0,0
Xgf180mcu_fd_sc_mcu9t5v0__fill_4_5 VDD VSS gf180mcu_fd_sc_mcu9t5v0__fill_4
* cell instance gf180mcu_fd_sc_mcu9t5v0__fill_4_6 r0 *1 0,0
Xgf180mcu_fd_sc_mcu9t5v0__fill_4_6 VDD VSS gf180mcu_fd_sc_mcu9t5v0__fill_4
* cell instance gf180mcu_fd_sc_mcu9t5v0__fill_4_7 r0 *1 0,0
Xgf180mcu_fd_sc_mcu9t5v0__fill_4_7 VDD VSS gf180mcu_fd_sc_mcu9t5v0__fill_4
* cell instance gf180mcu_fd_sc_mcu9t5v0__fill_4_8 r0 *1 0,0
Xgf180mcu_fd_sc_mcu9t5v0__fill_4_8 VDD VSS gf180mcu_fd_sc_mcu9t5v0__fill_4
* cell instance gf180mcu_fd_sc_mcu9t5v0__fill_4_9 r0 *1 0,0
Xgf180mcu_fd_sc_mcu9t5v0__fill_4_9 VDD VSS gf180mcu_fd_sc_mcu9t5v0__fill_4
* cell instance gf180mcu_fd_sc_mcu9t5v0__fill_4_10 r0 *1 0,0
Xgf180mcu_fd_sc_mcu9t5v0__fill_4_10 VDD VSS gf180mcu_fd_sc_mcu9t5v0__fill_4
* cell instance gf180mcu_fd_sc_mcu9t5v0__fill_4_11 r0 *1 0,0
Xgf180mcu_fd_sc_mcu9t5v0__fill_4_11 VDD VSS gf180mcu_fd_sc_mcu9t5v0__fill_4
* cell instance gf180mcu_fd_sc_mcu9t5v0__fill_4_12 r0 *1 0,0
Xgf180mcu_fd_sc_mcu9t5v0__fill_4_12 VDD VSS gf180mcu_fd_sc_mcu9t5v0__fill_4
* cell instance gf180mcu_fd_sc_mcu9t5v0__fill_4_13 r0 *1 0,0
Xgf180mcu_fd_sc_mcu9t5v0__fill_4_13 VDD VSS gf180mcu_fd_sc_mcu9t5v0__fill_4
* cell instance gf180mcu_fd_sc_mcu9t5v0__fill_4_14 r0 *1 0,0
Xgf180mcu_fd_sc_mcu9t5v0__fill_4_14 VDD VSS gf180mcu_fd_sc_mcu9t5v0__fill_4
* cell instance gf180mcu_fd_sc_mcu9t5v0__fill_4_15 r0 *1 0,0
Xgf180mcu_fd_sc_mcu9t5v0__fill_4_15 VDD VSS gf180mcu_fd_sc_mcu9t5v0__fill_4
* cell instance gf180mcu_fd_sc_mcu9t5v0__fill_4_16 r0 *1 0,0
Xgf180mcu_fd_sc_mcu9t5v0__fill_4_16 VDD VSS gf180mcu_fd_sc_mcu9t5v0__fill_4
* cell instance gf180mcu_fd_sc_mcu9t5v0__fill_4_17 r0 *1 0,0
Xgf180mcu_fd_sc_mcu9t5v0__fill_4_17 VDD VSS gf180mcu_fd_sc_mcu9t5v0__fill_4
* cell instance gf180mcu_fd_sc_mcu9t5v0__fill_4_18 r0 *1 0,0
Xgf180mcu_fd_sc_mcu9t5v0__fill_4_18 VDD VSS gf180mcu_fd_sc_mcu9t5v0__fill_4
* cell instance gf180mcu_fd_sc_mcu9t5v0__fill_4_19 r0 *1 0,0
Xgf180mcu_fd_sc_mcu9t5v0__fill_4_19 VDD VSS gf180mcu_fd_sc_mcu9t5v0__fill_4
* cell instance gf180mcu_fd_sc_mcu9t5v0__fill_4_20 r0 *1 0,0
Xgf180mcu_fd_sc_mcu9t5v0__fill_4_20 VDD VSS gf180mcu_fd_sc_mcu9t5v0__fill_4
* cell instance gf180mcu_fd_sc_mcu9t5v0__fill_4_21 r0 *1 0,0
Xgf180mcu_fd_sc_mcu9t5v0__fill_4_21 VDD VSS gf180mcu_fd_sc_mcu9t5v0__fill_4
* cell instance gf180mcu_fd_sc_mcu9t5v0__fill_4_22 r0 *1 0,0
Xgf180mcu_fd_sc_mcu9t5v0__fill_4_22 VDD VSS gf180mcu_fd_sc_mcu9t5v0__fill_4
* cell instance gf180mcu_fd_sc_mcu9t5v0__fill_4_23 r0 *1 0,0
Xgf180mcu_fd_sc_mcu9t5v0__fill_4_23 VDD VSS gf180mcu_fd_sc_mcu9t5v0__fill_4
* cell instance gf180mcu_fd_sc_mcu9t5v0__fill_4_24 r0 *1 0,0
Xgf180mcu_fd_sc_mcu9t5v0__fill_4_24 VDD VSS gf180mcu_fd_sc_mcu9t5v0__fill_4
* cell instance gf180mcu_fd_sc_mcu9t5v0__fill_4_25 r0 *1 0,0
Xgf180mcu_fd_sc_mcu9t5v0__fill_4_25 VDD VSS gf180mcu_fd_sc_mcu9t5v0__fill_4
* cell instance gf180mcu_fd_sc_mcu9t5v0__fill_4_26 r0 *1 0,0
Xgf180mcu_fd_sc_mcu9t5v0__fill_4_26 VDD VSS gf180mcu_fd_sc_mcu9t5v0__fill_4
* cell instance gf180mcu_fd_sc_mcu9t5v0__fill_4_27 r0 *1 0,0
Xgf180mcu_fd_sc_mcu9t5v0__fill_4_27 VDD VSS gf180mcu_fd_sc_mcu9t5v0__fill_4
* cell instance gf180mcu_fd_sc_mcu9t5v0__fill_4_28 r0 *1 0,0
Xgf180mcu_fd_sc_mcu9t5v0__fill_4_28 VDD VSS gf180mcu_fd_sc_mcu9t5v0__fill_4
* cell instance gf180mcu_fd_sc_mcu9t5v0__fill_4_29 r0 *1 0,0
Xgf180mcu_fd_sc_mcu9t5v0__fill_4_29 VDD VSS gf180mcu_fd_sc_mcu9t5v0__fill_4
* cell instance gf180mcu_fd_sc_mcu9t5v0__fill_4_30 r0 *1 0,0
Xgf180mcu_fd_sc_mcu9t5v0__fill_4_30 VDD VSS gf180mcu_fd_sc_mcu9t5v0__fill_4
* cell instance gf180mcu_fd_sc_mcu9t5v0__fill_4_31 r0 *1 0,0
Xgf180mcu_fd_sc_mcu9t5v0__fill_4_31 VDD VSS gf180mcu_fd_sc_mcu9t5v0__fill_4
* cell instance gf180mcu_fd_sc_mcu9t5v0__fill_4_32 r0 *1 0,0
Xgf180mcu_fd_sc_mcu9t5v0__fill_4_32 VDD VSS gf180mcu_fd_sc_mcu9t5v0__fill_4
* cell instance gf180mcu_fd_sc_mcu9t5v0__fill_4_33 r0 *1 0,0
Xgf180mcu_fd_sc_mcu9t5v0__fill_4_33 VDD VSS gf180mcu_fd_sc_mcu9t5v0__fill_4
* cell instance gf180mcu_fd_sc_mcu9t5v0__fill_4_34 r0 *1 0,0
Xgf180mcu_fd_sc_mcu9t5v0__fill_4_34 VDD VSS gf180mcu_fd_sc_mcu9t5v0__fill_4
* cell instance gf180mcu_fd_sc_mcu9t5v0__fill_4_35 r0 *1 0,0
Xgf180mcu_fd_sc_mcu9t5v0__fill_4_35 VDD VSS gf180mcu_fd_sc_mcu9t5v0__fill_4
* cell instance gf180mcu_fd_sc_mcu9t5v0__fill_4_36 r0 *1 0,0
Xgf180mcu_fd_sc_mcu9t5v0__fill_4_36 VDD VSS gf180mcu_fd_sc_mcu9t5v0__fill_4
* cell instance gf180mcu_fd_sc_mcu9t5v0__fill_4_37 r0 *1 0,0
Xgf180mcu_fd_sc_mcu9t5v0__fill_4_37 VDD VSS gf180mcu_fd_sc_mcu9t5v0__fill_4
* cell instance gf180mcu_fd_sc_mcu9t5v0__fill_4_38 r0 *1 0,0
Xgf180mcu_fd_sc_mcu9t5v0__fill_4_38 VDD VSS gf180mcu_fd_sc_mcu9t5v0__fill_4
* cell instance gf180mcu_fd_sc_mcu9t5v0__fill_4_39 r0 *1 0,0
Xgf180mcu_fd_sc_mcu9t5v0__fill_4_39 VDD VSS gf180mcu_fd_sc_mcu9t5v0__fill_4
* cell instance gf180mcu_fd_sc_mcu9t5v0__fill_4_40 r0 *1 0,0
Xgf180mcu_fd_sc_mcu9t5v0__fill_4_40 VDD VSS gf180mcu_fd_sc_mcu9t5v0__fill_4
* cell instance gf180mcu_fd_sc_mcu9t5v0__fill_4_41 r0 *1 0,0
Xgf180mcu_fd_sc_mcu9t5v0__fill_4_41 VDD VSS gf180mcu_fd_sc_mcu9t5v0__fill_4
* cell instance gf180mcu_fd_sc_mcu9t5v0__fill_4_42 r0 *1 0,0
Xgf180mcu_fd_sc_mcu9t5v0__fill_4_42 VDD VSS gf180mcu_fd_sc_mcu9t5v0__fill_4
* cell instance gf180mcu_fd_sc_mcu9t5v0__fill_4_43 r0 *1 0,0
Xgf180mcu_fd_sc_mcu9t5v0__fill_4_43 VDD VSS gf180mcu_fd_sc_mcu9t5v0__fill_4
* cell instance gf180mcu_fd_sc_mcu9t5v0__fill_4_44 r0 *1 0,0
Xgf180mcu_fd_sc_mcu9t5v0__fill_4_44 VDD VSS gf180mcu_fd_sc_mcu9t5v0__fill_4
* cell instance gf180mcu_fd_sc_mcu9t5v0__fill_4_45 r0 *1 0,0
Xgf180mcu_fd_sc_mcu9t5v0__fill_4_45 VDD VSS gf180mcu_fd_sc_mcu9t5v0__fill_4
* cell instance gf180mcu_fd_sc_mcu9t5v0__fill_4_46 r0 *1 0,0
Xgf180mcu_fd_sc_mcu9t5v0__fill_4_46 VDD VSS gf180mcu_fd_sc_mcu9t5v0__fill_4
* cell instance gf180mcu_fd_sc_mcu9t5v0__fill_4_47 r0 *1 0,0
Xgf180mcu_fd_sc_mcu9t5v0__fill_4_47 VDD VSS gf180mcu_fd_sc_mcu9t5v0__fill_4
* cell instance gf180mcu_fd_sc_mcu9t5v0__fill_4_48 r0 *1 0,0
Xgf180mcu_fd_sc_mcu9t5v0__fill_4_48 VDD VSS gf180mcu_fd_sc_mcu9t5v0__fill_4
* cell instance gf180mcu_fd_sc_mcu9t5v0__fill_4_49 r0 *1 0,0
Xgf180mcu_fd_sc_mcu9t5v0__fill_4_49 VDD VSS gf180mcu_fd_sc_mcu9t5v0__fill_4
* cell instance gf180mcu_fd_sc_mcu9t5v0__fill_4_50 r0 *1 0,0
Xgf180mcu_fd_sc_mcu9t5v0__fill_4_50 VDD VSS gf180mcu_fd_sc_mcu9t5v0__fill_4
* cell instance gf180mcu_fd_sc_mcu9t5v0__fill_4_51 r0 *1 0,0
Xgf180mcu_fd_sc_mcu9t5v0__fill_4_51 VDD VSS gf180mcu_fd_sc_mcu9t5v0__fill_4
* cell instance gf180mcu_fd_sc_mcu9t5v0__fill_4_52 r0 *1 0,0
Xgf180mcu_fd_sc_mcu9t5v0__fill_4_52 VDD VSS gf180mcu_fd_sc_mcu9t5v0__fill_4
* cell instance gf180mcu_fd_sc_mcu9t5v0__fill_4_53 r0 *1 0,0
Xgf180mcu_fd_sc_mcu9t5v0__fill_4_53 VDD VSS gf180mcu_fd_sc_mcu9t5v0__fill_4
* cell instance gf180mcu_fd_sc_mcu9t5v0__fill_4_54 r0 *1 0,0
Xgf180mcu_fd_sc_mcu9t5v0__fill_4_54 VDD VSS gf180mcu_fd_sc_mcu9t5v0__fill_4
* cell instance gf180mcu_fd_sc_mcu9t5v0__fill_4_55 r0 *1 0,0
Xgf180mcu_fd_sc_mcu9t5v0__fill_4_55 VDD VSS gf180mcu_fd_sc_mcu9t5v0__fill_4
* cell instance gf180mcu_fd_sc_mcu9t5v0__fill_4_56 r0 *1 0,0
Xgf180mcu_fd_sc_mcu9t5v0__fill_4_56 VDD VSS gf180mcu_fd_sc_mcu9t5v0__fill_4
* cell instance gf180mcu_fd_sc_mcu9t5v0__fill_4_57 r0 *1 0,0
Xgf180mcu_fd_sc_mcu9t5v0__fill_4_57 VDD VSS gf180mcu_fd_sc_mcu9t5v0__fill_4
* cell instance gf180mcu_fd_sc_mcu9t5v0__fill_4_58 r0 *1 0,0
Xgf180mcu_fd_sc_mcu9t5v0__fill_4_58 VDD VSS gf180mcu_fd_sc_mcu9t5v0__fill_4
* cell instance gf180mcu_fd_sc_mcu9t5v0__fill_4_59 r0 *1 0,0
Xgf180mcu_fd_sc_mcu9t5v0__fill_4_59 VDD VSS gf180mcu_fd_sc_mcu9t5v0__fill_4
* cell instance gf180mcu_fd_sc_mcu9t5v0__fill_4_60 r0 *1 0,0
Xgf180mcu_fd_sc_mcu9t5v0__fill_4_60 VDD VSS gf180mcu_fd_sc_mcu9t5v0__fill_4
* cell instance gf180mcu_fd_sc_mcu9t5v0__fill_4_61 r0 *1 0,0
Xgf180mcu_fd_sc_mcu9t5v0__fill_4_61 VDD VSS gf180mcu_fd_sc_mcu9t5v0__fill_4
* cell instance gf180mcu_fd_sc_mcu9t5v0__fill_4_62 r0 *1 0,0
Xgf180mcu_fd_sc_mcu9t5v0__fill_4_62 VDD VSS gf180mcu_fd_sc_mcu9t5v0__fill_4
* cell instance gf180mcu_fd_sc_mcu9t5v0__fill_4_63 r0 *1 0,0
Xgf180mcu_fd_sc_mcu9t5v0__fill_4_63 VDD VSS gf180mcu_fd_sc_mcu9t5v0__fill_4
* cell instance gf180mcu_fd_sc_mcu9t5v0__fill_4_64 r0 *1 0,0
Xgf180mcu_fd_sc_mcu9t5v0__fill_4_64 VDD VSS gf180mcu_fd_sc_mcu9t5v0__fill_4
* cell instance gf180mcu_fd_sc_mcu9t5v0__fill_4_65 r0 *1 0,0
Xgf180mcu_fd_sc_mcu9t5v0__fill_4_65 VDD VSS gf180mcu_fd_sc_mcu9t5v0__fill_4
* cell instance gf180mcu_fd_sc_mcu9t5v0__fill_4_66 r0 *1 0,0
Xgf180mcu_fd_sc_mcu9t5v0__fill_4_66 VDD VSS gf180mcu_fd_sc_mcu9t5v0__fill_4
* cell instance gf180mcu_fd_sc_mcu9t5v0__fill_4_67 r0 *1 0,0
Xgf180mcu_fd_sc_mcu9t5v0__fill_4_67 VDD VSS gf180mcu_fd_sc_mcu9t5v0__fill_4
* cell instance gf180mcu_fd_sc_mcu9t5v0__fill_4_68 r0 *1 0,0
Xgf180mcu_fd_sc_mcu9t5v0__fill_4_68 VDD VSS gf180mcu_fd_sc_mcu9t5v0__fill_4
* cell instance gf180mcu_fd_sc_mcu9t5v0__fill_4_69 r0 *1 0,0
Xgf180mcu_fd_sc_mcu9t5v0__fill_4_69 VDD VSS gf180mcu_fd_sc_mcu9t5v0__fill_4
* cell instance gf180mcu_fd_sc_mcu9t5v0__fill_4_70 r0 *1 0,0
Xgf180mcu_fd_sc_mcu9t5v0__fill_4_70 VDD VSS gf180mcu_fd_sc_mcu9t5v0__fill_4
* cell instance gf180mcu_fd_sc_mcu9t5v0__fill_4_71 r0 *1 0,0
Xgf180mcu_fd_sc_mcu9t5v0__fill_4_71 VDD VSS gf180mcu_fd_sc_mcu9t5v0__fill_4
* cell instance gf180mcu_fd_sc_mcu9t5v0__fill_4_72 r0 *1 0,0
Xgf180mcu_fd_sc_mcu9t5v0__fill_4_72 VDD VSS gf180mcu_fd_sc_mcu9t5v0__fill_4
* cell instance gf180mcu_fd_sc_mcu9t5v0__fill_4_73 r0 *1 0,0
Xgf180mcu_fd_sc_mcu9t5v0__fill_4_73 VDD VSS gf180mcu_fd_sc_mcu9t5v0__fill_4
* cell instance gf180mcu_fd_sc_mcu9t5v0__fill_4_74 r0 *1 0,0
Xgf180mcu_fd_sc_mcu9t5v0__fill_4_74 VDD VSS gf180mcu_fd_sc_mcu9t5v0__fill_4
* cell instance gf180mcu_fd_sc_mcu9t5v0__fill_4_75 r0 *1 0,0
Xgf180mcu_fd_sc_mcu9t5v0__fill_4_75 VDD VSS gf180mcu_fd_sc_mcu9t5v0__fill_4
* cell instance gf180mcu_fd_sc_mcu9t5v0__fill_4_76 r0 *1 0,0
Xgf180mcu_fd_sc_mcu9t5v0__fill_4_76 VDD VSS gf180mcu_fd_sc_mcu9t5v0__fill_4
* cell instance gf180mcu_fd_sc_mcu9t5v0__fill_4_77 r0 *1 0,0
Xgf180mcu_fd_sc_mcu9t5v0__fill_4_77 VDD VSS gf180mcu_fd_sc_mcu9t5v0__fill_4
* cell instance gf180mcu_fd_sc_mcu9t5v0__fill_4_78 r0 *1 0,0
Xgf180mcu_fd_sc_mcu9t5v0__fill_4_78 VDD VSS gf180mcu_fd_sc_mcu9t5v0__fill_4
* cell instance gf180mcu_fd_sc_mcu9t5v0__fill_4_79 r0 *1 0,0
Xgf180mcu_fd_sc_mcu9t5v0__fill_4_79 VDD VSS gf180mcu_fd_sc_mcu9t5v0__fill_4
* cell instance gf180mcu_fd_sc_mcu9t5v0__fill_4_80 r0 *1 0,0
Xgf180mcu_fd_sc_mcu9t5v0__fill_4_80 VDD VSS gf180mcu_fd_sc_mcu9t5v0__fill_4
* cell instance gf180mcu_fd_sc_mcu9t5v0__fill_4_81 r0 *1 0,0
Xgf180mcu_fd_sc_mcu9t5v0__fill_4_81 VDD VSS gf180mcu_fd_sc_mcu9t5v0__fill_4
* cell instance gf180mcu_fd_sc_mcu9t5v0__fill_4_82 r0 *1 0,0
Xgf180mcu_fd_sc_mcu9t5v0__fill_4_82 VDD VSS gf180mcu_fd_sc_mcu9t5v0__fill_4
* cell instance gf180mcu_fd_sc_mcu9t5v0__fill_4_83 r0 *1 0,0
Xgf180mcu_fd_sc_mcu9t5v0__fill_4_83 VDD VSS gf180mcu_fd_sc_mcu9t5v0__fill_4
* cell instance gf180mcu_fd_sc_mcu9t5v0__fill_4_84 r0 *1 0,0
Xgf180mcu_fd_sc_mcu9t5v0__fill_4_84 VDD VSS gf180mcu_fd_sc_mcu9t5v0__fill_4
* cell instance gf180mcu_fd_sc_mcu9t5v0__fill_4_85 r0 *1 0,0
Xgf180mcu_fd_sc_mcu9t5v0__fill_4_85 VDD VSS gf180mcu_fd_sc_mcu9t5v0__fill_4
* cell instance gf180mcu_fd_sc_mcu9t5v0__fill_4_86 r0 *1 0,0
Xgf180mcu_fd_sc_mcu9t5v0__fill_4_86 VDD VSS gf180mcu_fd_sc_mcu9t5v0__fill_4
* cell instance gf180mcu_fd_sc_mcu9t5v0__fill_4_87 r0 *1 0,0
Xgf180mcu_fd_sc_mcu9t5v0__fill_4_87 VDD VSS gf180mcu_fd_sc_mcu9t5v0__fill_4
* cell instance gf180mcu_fd_sc_mcu9t5v0__fill_4_88 r0 *1 0,0
Xgf180mcu_fd_sc_mcu9t5v0__fill_4_88 VDD VSS gf180mcu_fd_sc_mcu9t5v0__fill_4
* cell instance gf180mcu_fd_sc_mcu9t5v0__fill_4_89 r0 *1 0,0
Xgf180mcu_fd_sc_mcu9t5v0__fill_4_89 VDD VSS gf180mcu_fd_sc_mcu9t5v0__fill_4
* cell instance gf180mcu_fd_sc_mcu9t5v0__fill_4_90 r0 *1 0,0
Xgf180mcu_fd_sc_mcu9t5v0__fill_4_90 VDD VSS gf180mcu_fd_sc_mcu9t5v0__fill_4
* cell instance gf180mcu_fd_sc_mcu9t5v0__fill_4_91 r0 *1 0,0
Xgf180mcu_fd_sc_mcu9t5v0__fill_4_91 VDD VSS gf180mcu_fd_sc_mcu9t5v0__fill_4
* cell instance gf180mcu_fd_sc_mcu9t5v0__fill_4_92 r0 *1 0,0
Xgf180mcu_fd_sc_mcu9t5v0__fill_4_92 VDD VSS gf180mcu_fd_sc_mcu9t5v0__fill_4
* cell instance gf180mcu_fd_sc_mcu9t5v0__fill_4_93 r0 *1 0,0
Xgf180mcu_fd_sc_mcu9t5v0__fill_4_93 VDD VSS gf180mcu_fd_sc_mcu9t5v0__fill_4
* cell instance gf180mcu_fd_sc_mcu9t5v0__fill_4_94 r0 *1 0,0
Xgf180mcu_fd_sc_mcu9t5v0__fill_4_94 VDD VSS gf180mcu_fd_sc_mcu9t5v0__fill_4
* cell instance gf180mcu_fd_sc_mcu9t5v0__fill_4_95 r0 *1 0,0
Xgf180mcu_fd_sc_mcu9t5v0__fill_4_95 VDD VSS gf180mcu_fd_sc_mcu9t5v0__fill_4
* cell instance gf180mcu_fd_sc_mcu9t5v0__fill_4_96 r0 *1 0,0
Xgf180mcu_fd_sc_mcu9t5v0__fill_4_96 VDD VSS gf180mcu_fd_sc_mcu9t5v0__fill_4
* cell instance gf180mcu_fd_sc_mcu9t5v0__fill_4_97 r0 *1 0,0
Xgf180mcu_fd_sc_mcu9t5v0__fill_4_97 VDD VSS gf180mcu_fd_sc_mcu9t5v0__fill_4
* cell instance gf180mcu_fd_sc_mcu9t5v0__fill_4_98 r0 *1 0,0
Xgf180mcu_fd_sc_mcu9t5v0__fill_4_98 VDD VSS gf180mcu_fd_sc_mcu9t5v0__fill_4
* cell instance gf180mcu_fd_sc_mcu9t5v0__fill_4_99 r0 *1 0,0
Xgf180mcu_fd_sc_mcu9t5v0__fill_4_99 VDD VSS gf180mcu_fd_sc_mcu9t5v0__fill_4
* cell instance gf180mcu_fd_sc_mcu9t5v0__fill_4_100 r0 *1 0,0
Xgf180mcu_fd_sc_mcu9t5v0__fill_4_100 VDD VSS gf180mcu_fd_sc_mcu9t5v0__fill_4
* cell instance gf180mcu_fd_sc_mcu9t5v0__fill_4_101 r0 *1 0,0
Xgf180mcu_fd_sc_mcu9t5v0__fill_4_101 VDD VSS gf180mcu_fd_sc_mcu9t5v0__fill_4
* cell instance gf180mcu_fd_sc_mcu9t5v0__fill_4_102 r0 *1 0,0
Xgf180mcu_fd_sc_mcu9t5v0__fill_4_102 VDD VSS gf180mcu_fd_sc_mcu9t5v0__fill_4
* cell instance gf180mcu_fd_sc_mcu9t5v0__fill_4_103 r0 *1 0,0
Xgf180mcu_fd_sc_mcu9t5v0__fill_4_103 VDD VSS gf180mcu_fd_sc_mcu9t5v0__fill_4
* cell instance gf180mcu_fd_sc_mcu9t5v0__fill_4_104 r0 *1 0,0
Xgf180mcu_fd_sc_mcu9t5v0__fill_4_104 VDD VSS gf180mcu_fd_sc_mcu9t5v0__fill_4
* cell instance gf180mcu_fd_sc_mcu9t5v0__fill_4_105 r0 *1 0,0
Xgf180mcu_fd_sc_mcu9t5v0__fill_4_105 VDD VSS gf180mcu_fd_sc_mcu9t5v0__fill_4
* cell instance gf180mcu_fd_sc_mcu9t5v0__fill_4_106 r0 *1 0,0
Xgf180mcu_fd_sc_mcu9t5v0__fill_4_106 VDD VSS gf180mcu_fd_sc_mcu9t5v0__fill_4
* cell instance gf180mcu_fd_sc_mcu9t5v0__fill_4_107 r0 *1 0,0
Xgf180mcu_fd_sc_mcu9t5v0__fill_4_107 VDD VSS gf180mcu_fd_sc_mcu9t5v0__fill_4
* cell instance gf180mcu_fd_sc_mcu9t5v0__fill_4_108 r0 *1 0,0
Xgf180mcu_fd_sc_mcu9t5v0__fill_4_108 VDD VSS gf180mcu_fd_sc_mcu9t5v0__fill_4
* cell instance gf180mcu_fd_sc_mcu9t5v0__fill_4_109 r0 *1 0,0
Xgf180mcu_fd_sc_mcu9t5v0__fill_4_109 VDD VSS gf180mcu_fd_sc_mcu9t5v0__fill_4
* cell instance gf180mcu_fd_sc_mcu9t5v0__fill_4_110 r0 *1 0,0
Xgf180mcu_fd_sc_mcu9t5v0__fill_4_110 VDD VSS gf180mcu_fd_sc_mcu9t5v0__fill_4
* cell instance gf180mcu_fd_sc_mcu9t5v0__fill_4_111 r0 *1 0,0
Xgf180mcu_fd_sc_mcu9t5v0__fill_4_111 VDD VSS gf180mcu_fd_sc_mcu9t5v0__fill_4
* cell instance gf180mcu_fd_sc_mcu9t5v0__fill_4_112 r0 *1 0,0
Xgf180mcu_fd_sc_mcu9t5v0__fill_4_112 VDD VSS gf180mcu_fd_sc_mcu9t5v0__fill_4
* cell instance gf180mcu_fd_sc_mcu9t5v0__fill_4_113 r0 *1 0,0
Xgf180mcu_fd_sc_mcu9t5v0__fill_4_113 VDD VSS gf180mcu_fd_sc_mcu9t5v0__fill_4
* cell instance gf180mcu_fd_sc_mcu9t5v0__fill_4_114 r0 *1 0,0
Xgf180mcu_fd_sc_mcu9t5v0__fill_4_114 VDD VSS gf180mcu_fd_sc_mcu9t5v0__fill_4
* cell instance gf180mcu_fd_sc_mcu9t5v0__fill_4_115 r0 *1 0,0
Xgf180mcu_fd_sc_mcu9t5v0__fill_4_115 VDD VSS gf180mcu_fd_sc_mcu9t5v0__fill_4
* cell instance gf180mcu_fd_sc_mcu9t5v0__fill_4_116 r0 *1 0,0
Xgf180mcu_fd_sc_mcu9t5v0__fill_4_116 VDD VSS gf180mcu_fd_sc_mcu9t5v0__fill_4
* cell instance gf180mcu_fd_sc_mcu9t5v0__fill_4_117 r0 *1 0,0
Xgf180mcu_fd_sc_mcu9t5v0__fill_4_117 VDD VSS gf180mcu_fd_sc_mcu9t5v0__fill_4
* cell instance gf180mcu_fd_sc_mcu9t5v0__fill_4_118 r0 *1 0,0
Xgf180mcu_fd_sc_mcu9t5v0__fill_4_118 VDD VSS gf180mcu_fd_sc_mcu9t5v0__fill_4
* cell instance gf180mcu_fd_sc_mcu9t5v0__fill_4_119 r0 *1 0,0
Xgf180mcu_fd_sc_mcu9t5v0__fill_4_119 VDD VSS gf180mcu_fd_sc_mcu9t5v0__fill_4
* cell instance gf180mcu_fd_sc_mcu9t5v0__fill_4_120 r0 *1 0,0
Xgf180mcu_fd_sc_mcu9t5v0__fill_4_120 VDD VSS gf180mcu_fd_sc_mcu9t5v0__fill_4
* cell instance gf180mcu_fd_sc_mcu9t5v0__fill_4_121 r0 *1 0,0
Xgf180mcu_fd_sc_mcu9t5v0__fill_4_121 VDD VSS gf180mcu_fd_sc_mcu9t5v0__fill_4
* cell instance gf180mcu_fd_sc_mcu9t5v0__fill_4_122 r0 *1 0,0
Xgf180mcu_fd_sc_mcu9t5v0__fill_4_122 VDD VSS gf180mcu_fd_sc_mcu9t5v0__fill_4
* cell instance gf180mcu_fd_sc_mcu9t5v0__fill_4_123 r0 *1 0,0
Xgf180mcu_fd_sc_mcu9t5v0__fill_4_123 VDD VSS gf180mcu_fd_sc_mcu9t5v0__fill_4
* cell instance gf180mcu_fd_sc_mcu9t5v0__fill_4_124 r0 *1 0,0
Xgf180mcu_fd_sc_mcu9t5v0__fill_4_124 VDD VSS gf180mcu_fd_sc_mcu9t5v0__fill_4
* cell instance gf180mcu_fd_sc_mcu9t5v0__fill_4_125 r0 *1 0,0
Xgf180mcu_fd_sc_mcu9t5v0__fill_4_125 VDD VSS gf180mcu_fd_sc_mcu9t5v0__fill_4
* cell instance gf180mcu_fd_sc_mcu9t5v0__fill_4_126 r0 *1 0,0
Xgf180mcu_fd_sc_mcu9t5v0__fill_4_126 VDD VSS gf180mcu_fd_sc_mcu9t5v0__fill_4
* cell instance gf180mcu_fd_sc_mcu9t5v0__fill_4_127 r0 *1 0,0
Xgf180mcu_fd_sc_mcu9t5v0__fill_4_127 VDD VSS gf180mcu_fd_sc_mcu9t5v0__fill_4
* cell instance gf180mcu_fd_sc_mcu9t5v0__fill_4_128 r0 *1 0,0
Xgf180mcu_fd_sc_mcu9t5v0__fill_4_128 VDD VSS gf180mcu_fd_sc_mcu9t5v0__fill_4
* cell instance gf180mcu_fd_sc_mcu9t5v0__fill_4_129 r0 *1 0,0
Xgf180mcu_fd_sc_mcu9t5v0__fill_4_129 VDD VSS gf180mcu_fd_sc_mcu9t5v0__fill_4
* cell instance gf180mcu_fd_sc_mcu9t5v0__fill_4_130 r0 *1 0,0
Xgf180mcu_fd_sc_mcu9t5v0__fill_4_130 VDD VSS gf180mcu_fd_sc_mcu9t5v0__fill_4
* cell instance gf180mcu_fd_sc_mcu9t5v0__fill_4_131 r0 *1 0,0
Xgf180mcu_fd_sc_mcu9t5v0__fill_4_131 VDD VSS gf180mcu_fd_sc_mcu9t5v0__fill_4
* cell instance gf180mcu_fd_sc_mcu9t5v0__fill_4_132 r0 *1 0,0
Xgf180mcu_fd_sc_mcu9t5v0__fill_4_132 VDD VSS gf180mcu_fd_sc_mcu9t5v0__fill_4
* cell instance gf180mcu_fd_sc_mcu9t5v0__fill_4_133 r0 *1 0,0
Xgf180mcu_fd_sc_mcu9t5v0__fill_4_133 VDD VSS gf180mcu_fd_sc_mcu9t5v0__fill_4
* cell instance gf180mcu_fd_sc_mcu9t5v0__fill_64_0 r0 *1 0,0
Xgf180mcu_fd_sc_mcu9t5v0__fill_64_0 VDD VSS gf180mcu_fd_sc_mcu9t5v0__fill_64
* cell instance gf180mcu_fd_sc_mcu9t5v0__fill_64_1 r0 *1 0,0
Xgf180mcu_fd_sc_mcu9t5v0__fill_64_1 VDD VSS gf180mcu_fd_sc_mcu9t5v0__fill_64
* cell instance gf180mcu_fd_sc_mcu9t5v0__fill_64_2 r0 *1 0,0
Xgf180mcu_fd_sc_mcu9t5v0__fill_64_2 VDD VSS gf180mcu_fd_sc_mcu9t5v0__fill_64
* cell instance gf180mcu_fd_sc_mcu9t5v0__fill_64_3 r0 *1 0,0
Xgf180mcu_fd_sc_mcu9t5v0__fill_64_3 VDD VSS gf180mcu_fd_sc_mcu9t5v0__fill_64
* cell instance gf180mcu_fd_sc_mcu9t5v0__fill_64_4 r0 *1 0,0
Xgf180mcu_fd_sc_mcu9t5v0__fill_64_4 VDD VSS gf180mcu_fd_sc_mcu9t5v0__fill_64
* cell instance gf180mcu_fd_sc_mcu9t5v0__fill_64_5 r0 *1 0,0
Xgf180mcu_fd_sc_mcu9t5v0__fill_64_5 VDD VSS gf180mcu_fd_sc_mcu9t5v0__fill_64
* cell instance gf180mcu_fd_sc_mcu9t5v0__fill_64_6 r0 *1 0,0
Xgf180mcu_fd_sc_mcu9t5v0__fill_64_6 VDD VSS gf180mcu_fd_sc_mcu9t5v0__fill_64
* cell instance gf180mcu_fd_sc_mcu9t5v0__fill_64_7 r0 *1 0,0
Xgf180mcu_fd_sc_mcu9t5v0__fill_64_7 VDD VSS gf180mcu_fd_sc_mcu9t5v0__fill_64
* cell instance gf180mcu_fd_sc_mcu9t5v0__fill_64_8 r0 *1 0,0
Xgf180mcu_fd_sc_mcu9t5v0__fill_64_8 VDD VSS gf180mcu_fd_sc_mcu9t5v0__fill_64
* cell instance gf180mcu_fd_sc_mcu9t5v0__fill_64_9 r0 *1 0,0
Xgf180mcu_fd_sc_mcu9t5v0__fill_64_9 VDD VSS gf180mcu_fd_sc_mcu9t5v0__fill_64
* cell instance gf180mcu_fd_sc_mcu9t5v0__fill_64_10 r0 *1 0,0
Xgf180mcu_fd_sc_mcu9t5v0__fill_64_10 VDD VSS gf180mcu_fd_sc_mcu9t5v0__fill_64
* cell instance gf180mcu_fd_sc_mcu9t5v0__fill_64_11 r0 *1 0,0
Xgf180mcu_fd_sc_mcu9t5v0__fill_64_11 VDD VSS gf180mcu_fd_sc_mcu9t5v0__fill_64
* cell instance gf180mcu_fd_sc_mcu9t5v0__fill_64_12 r0 *1 0,0
Xgf180mcu_fd_sc_mcu9t5v0__fill_64_12 VDD VSS gf180mcu_fd_sc_mcu9t5v0__fill_64
* cell instance gf180mcu_fd_sc_mcu9t5v0__fill_64_13 r0 *1 0,0
Xgf180mcu_fd_sc_mcu9t5v0__fill_64_13 VDD VSS gf180mcu_fd_sc_mcu9t5v0__fill_64
* cell instance gf180mcu_fd_sc_mcu9t5v0__fill_64_14 r0 *1 0,0
Xgf180mcu_fd_sc_mcu9t5v0__fill_64_14 VDD VSS gf180mcu_fd_sc_mcu9t5v0__fill_64
* cell instance gf180mcu_fd_sc_mcu9t5v0__fill_64_15 r0 *1 0,0
Xgf180mcu_fd_sc_mcu9t5v0__fill_64_15 VDD VSS gf180mcu_fd_sc_mcu9t5v0__fill_64
* cell instance gf180mcu_fd_sc_mcu9t5v0__fill_64_16 r0 *1 0,0
Xgf180mcu_fd_sc_mcu9t5v0__fill_64_16 VDD VSS gf180mcu_fd_sc_mcu9t5v0__fill_64
* cell instance gf180mcu_fd_sc_mcu9t5v0__fill_64_17 r0 *1 0,0
Xgf180mcu_fd_sc_mcu9t5v0__fill_64_17 VDD VSS gf180mcu_fd_sc_mcu9t5v0__fill_64
* cell instance gf180mcu_fd_sc_mcu9t5v0__fill_64_18 r0 *1 0,0
Xgf180mcu_fd_sc_mcu9t5v0__fill_64_18 VDD VSS gf180mcu_fd_sc_mcu9t5v0__fill_64
* cell instance gf180mcu_fd_sc_mcu9t5v0__fill_64_19 r0 *1 0,0
Xgf180mcu_fd_sc_mcu9t5v0__fill_64_19 VDD VSS gf180mcu_fd_sc_mcu9t5v0__fill_64
* cell instance gf180mcu_fd_sc_mcu9t5v0__fill_64_20 r0 *1 0,0
Xgf180mcu_fd_sc_mcu9t5v0__fill_64_20 VDD VSS gf180mcu_fd_sc_mcu9t5v0__fill_64
* cell instance gf180mcu_fd_sc_mcu9t5v0__fill_64_21 r0 *1 0,0
Xgf180mcu_fd_sc_mcu9t5v0__fill_64_21 VDD VSS gf180mcu_fd_sc_mcu9t5v0__fill_64
* cell instance gf180mcu_fd_sc_mcu9t5v0__fill_64_22 r0 *1 0,0
Xgf180mcu_fd_sc_mcu9t5v0__fill_64_22 VDD VSS gf180mcu_fd_sc_mcu9t5v0__fill_64
* cell instance gf180mcu_fd_sc_mcu9t5v0__fill_64_23 r0 *1 0,0
Xgf180mcu_fd_sc_mcu9t5v0__fill_64_23 VDD VSS gf180mcu_fd_sc_mcu9t5v0__fill_64
* cell instance gf180mcu_fd_sc_mcu9t5v0__fill_64_24 r0 *1 0,0
Xgf180mcu_fd_sc_mcu9t5v0__fill_64_24 VDD VSS gf180mcu_fd_sc_mcu9t5v0__fill_64
* cell instance gf180mcu_fd_sc_mcu9t5v0__fill_64_25 r0 *1 0,0
Xgf180mcu_fd_sc_mcu9t5v0__fill_64_25 VDD VSS gf180mcu_fd_sc_mcu9t5v0__fill_64
* cell instance gf180mcu_fd_sc_mcu9t5v0__fill_64_26 r0 *1 0,0
Xgf180mcu_fd_sc_mcu9t5v0__fill_64_26 VDD VSS gf180mcu_fd_sc_mcu9t5v0__fill_64
* cell instance gf180mcu_fd_sc_mcu9t5v0__fill_64_27 r0 *1 0,0
Xgf180mcu_fd_sc_mcu9t5v0__fill_64_27 VDD VSS gf180mcu_fd_sc_mcu9t5v0__fill_64
* cell instance gf180mcu_fd_sc_mcu9t5v0__fill_64_28 r0 *1 0,0
Xgf180mcu_fd_sc_mcu9t5v0__fill_64_28 VDD VSS gf180mcu_fd_sc_mcu9t5v0__fill_64
* cell instance gf180mcu_fd_sc_mcu9t5v0__fill_64_29 r0 *1 0,0
Xgf180mcu_fd_sc_mcu9t5v0__fill_64_29 VDD VSS gf180mcu_fd_sc_mcu9t5v0__fill_64
* cell instance gf180mcu_fd_sc_mcu9t5v0__fill_64_30 r0 *1 0,0
Xgf180mcu_fd_sc_mcu9t5v0__fill_64_30 VDD VSS gf180mcu_fd_sc_mcu9t5v0__fill_64
* cell instance gf180mcu_fd_sc_mcu9t5v0__fill_64_31 r0 *1 0,0
Xgf180mcu_fd_sc_mcu9t5v0__fill_64_31 VDD VSS gf180mcu_fd_sc_mcu9t5v0__fill_64
* cell instance gf180mcu_fd_sc_mcu9t5v0__fill_64_32 r0 *1 0,0
Xgf180mcu_fd_sc_mcu9t5v0__fill_64_32 VDD VSS gf180mcu_fd_sc_mcu9t5v0__fill_64
* cell instance gf180mcu_fd_sc_mcu9t5v0__fill_8_0 r0 *1 0,0
Xgf180mcu_fd_sc_mcu9t5v0__fill_8_0 VDD VSS gf180mcu_fd_sc_mcu9t5v0__fill_8
* cell instance gf180mcu_fd_sc_mcu9t5v0__fill_8_1 r0 *1 0,0
Xgf180mcu_fd_sc_mcu9t5v0__fill_8_1 VDD VSS gf180mcu_fd_sc_mcu9t5v0__fill_8
* cell instance gf180mcu_fd_sc_mcu9t5v0__fill_8_2 r0 *1 0,0
Xgf180mcu_fd_sc_mcu9t5v0__fill_8_2 VDD VSS gf180mcu_fd_sc_mcu9t5v0__fill_8
* cell instance gf180mcu_fd_sc_mcu9t5v0__fill_8_3 r0 *1 0,0
Xgf180mcu_fd_sc_mcu9t5v0__fill_8_3 VDD VSS gf180mcu_fd_sc_mcu9t5v0__fill_8
* cell instance gf180mcu_fd_sc_mcu9t5v0__fill_8_4 r0 *1 0,0
Xgf180mcu_fd_sc_mcu9t5v0__fill_8_4 VDD VSS gf180mcu_fd_sc_mcu9t5v0__fill_8
* cell instance gf180mcu_fd_sc_mcu9t5v0__fill_8_5 r0 *1 0,0
Xgf180mcu_fd_sc_mcu9t5v0__fill_8_5 VDD VSS gf180mcu_fd_sc_mcu9t5v0__fill_8
* cell instance gf180mcu_fd_sc_mcu9t5v0__fill_8_6 r0 *1 0,0
Xgf180mcu_fd_sc_mcu9t5v0__fill_8_6 VDD VSS gf180mcu_fd_sc_mcu9t5v0__fill_8
* cell instance gf180mcu_fd_sc_mcu9t5v0__fill_8_7 r0 *1 0,0
Xgf180mcu_fd_sc_mcu9t5v0__fill_8_7 VDD VSS gf180mcu_fd_sc_mcu9t5v0__fill_8
* cell instance gf180mcu_fd_sc_mcu9t5v0__fill_8_8 r0 *1 0,0
Xgf180mcu_fd_sc_mcu9t5v0__fill_8_8 VDD VSS gf180mcu_fd_sc_mcu9t5v0__fill_8
* cell instance gf180mcu_fd_sc_mcu9t5v0__fill_8_9 r0 *1 0,0
Xgf180mcu_fd_sc_mcu9t5v0__fill_8_9 VDD VSS gf180mcu_fd_sc_mcu9t5v0__fill_8
* cell instance gf180mcu_fd_sc_mcu9t5v0__fill_8_10 r0 *1 0,0
Xgf180mcu_fd_sc_mcu9t5v0__fill_8_10 VDD VSS gf180mcu_fd_sc_mcu9t5v0__fill_8
* cell instance gf180mcu_fd_sc_mcu9t5v0__fill_8_11 r0 *1 0,0
Xgf180mcu_fd_sc_mcu9t5v0__fill_8_11 VDD VSS gf180mcu_fd_sc_mcu9t5v0__fill_8
* cell instance gf180mcu_fd_sc_mcu9t5v0__fill_8_12 r0 *1 0,0
Xgf180mcu_fd_sc_mcu9t5v0__fill_8_12 VDD VSS gf180mcu_fd_sc_mcu9t5v0__fill_8
* cell instance gf180mcu_fd_sc_mcu9t5v0__fill_8_13 r0 *1 0,0
Xgf180mcu_fd_sc_mcu9t5v0__fill_8_13 VDD VSS gf180mcu_fd_sc_mcu9t5v0__fill_8
* cell instance gf180mcu_fd_sc_mcu9t5v0__fill_8_14 r0 *1 0,0
Xgf180mcu_fd_sc_mcu9t5v0__fill_8_14 VDD VSS gf180mcu_fd_sc_mcu9t5v0__fill_8
* cell instance gf180mcu_fd_sc_mcu9t5v0__fill_8_15 r0 *1 0,0
Xgf180mcu_fd_sc_mcu9t5v0__fill_8_15 VDD VSS gf180mcu_fd_sc_mcu9t5v0__fill_8
* cell instance gf180mcu_fd_sc_mcu9t5v0__fill_8_16 r0 *1 0,0
Xgf180mcu_fd_sc_mcu9t5v0__fill_8_16 VDD VSS gf180mcu_fd_sc_mcu9t5v0__fill_8
* cell instance gf180mcu_fd_sc_mcu9t5v0__fill_8_17 r0 *1 0,0
Xgf180mcu_fd_sc_mcu9t5v0__fill_8_17 VDD VSS gf180mcu_fd_sc_mcu9t5v0__fill_8
* cell instance gf180mcu_fd_sc_mcu9t5v0__fill_8_18 r0 *1 0,0
Xgf180mcu_fd_sc_mcu9t5v0__fill_8_18 VDD VSS gf180mcu_fd_sc_mcu9t5v0__fill_8
* cell instance gf180mcu_fd_sc_mcu9t5v0__fill_8_19 r0 *1 0,0
Xgf180mcu_fd_sc_mcu9t5v0__fill_8_19 VDD VSS gf180mcu_fd_sc_mcu9t5v0__fill_8
* cell instance gf180mcu_fd_sc_mcu9t5v0__fill_8_20 r0 *1 0,0
Xgf180mcu_fd_sc_mcu9t5v0__fill_8_20 VDD VSS gf180mcu_fd_sc_mcu9t5v0__fill_8
* cell instance gf180mcu_fd_sc_mcu9t5v0__fill_8_21 r0 *1 0,0
Xgf180mcu_fd_sc_mcu9t5v0__fill_8_21 VDD VSS gf180mcu_fd_sc_mcu9t5v0__fill_8
* cell instance gf180mcu_fd_sc_mcu9t5v0__fill_8_22 r0 *1 0,0
Xgf180mcu_fd_sc_mcu9t5v0__fill_8_22 VDD VSS gf180mcu_fd_sc_mcu9t5v0__fill_8
* cell instance gf180mcu_fd_sc_mcu9t5v0__fill_8_23 r0 *1 0,0
Xgf180mcu_fd_sc_mcu9t5v0__fill_8_23 VDD VSS gf180mcu_fd_sc_mcu9t5v0__fill_8
* cell instance gf180mcu_fd_sc_mcu9t5v0__fill_8_24 r0 *1 0,0
Xgf180mcu_fd_sc_mcu9t5v0__fill_8_24 VDD VSS gf180mcu_fd_sc_mcu9t5v0__fill_8
* cell instance gf180mcu_fd_sc_mcu9t5v0__fill_8_25 r0 *1 0,0
Xgf180mcu_fd_sc_mcu9t5v0__fill_8_25 VDD VSS gf180mcu_fd_sc_mcu9t5v0__fill_8
* cell instance gf180mcu_fd_sc_mcu9t5v0__fill_8_26 r0 *1 0,0
Xgf180mcu_fd_sc_mcu9t5v0__fill_8_26 VDD VSS gf180mcu_fd_sc_mcu9t5v0__fill_8
* cell instance gf180mcu_fd_sc_mcu9t5v0__fill_8_27 r0 *1 0,0
Xgf180mcu_fd_sc_mcu9t5v0__fill_8_27 VDD VSS gf180mcu_fd_sc_mcu9t5v0__fill_8
* cell instance gf180mcu_fd_sc_mcu9t5v0__fill_8_28 r0 *1 0,0
Xgf180mcu_fd_sc_mcu9t5v0__fill_8_28 VDD VSS gf180mcu_fd_sc_mcu9t5v0__fill_8
* cell instance gf180mcu_fd_sc_mcu9t5v0__fill_8_29 r0 *1 0,0
Xgf180mcu_fd_sc_mcu9t5v0__fill_8_29 VDD VSS gf180mcu_fd_sc_mcu9t5v0__fill_8
* cell instance gf180mcu_fd_sc_mcu9t5v0__fill_8_30 r0 *1 0,0
Xgf180mcu_fd_sc_mcu9t5v0__fill_8_30 VDD VSS gf180mcu_fd_sc_mcu9t5v0__fill_8
* cell instance gf180mcu_fd_sc_mcu9t5v0__fill_8_31 r0 *1 0,0
Xgf180mcu_fd_sc_mcu9t5v0__fill_8_31 VDD VSS gf180mcu_fd_sc_mcu9t5v0__fill_8
* cell instance gf180mcu_fd_sc_mcu9t5v0__fill_8_32 r0 *1 0,0
Xgf180mcu_fd_sc_mcu9t5v0__fill_8_32 VDD VSS gf180mcu_fd_sc_mcu9t5v0__fill_8
* cell instance gf180mcu_fd_sc_mcu9t5v0__fill_8_33 r0 *1 0,0
Xgf180mcu_fd_sc_mcu9t5v0__fill_8_33 VDD VSS gf180mcu_fd_sc_mcu9t5v0__fill_8
* cell instance gf180mcu_fd_sc_mcu9t5v0__fill_8_34 r0 *1 0,0
Xgf180mcu_fd_sc_mcu9t5v0__fill_8_34 VDD VSS gf180mcu_fd_sc_mcu9t5v0__fill_8
* cell instance gf180mcu_fd_sc_mcu9t5v0__fill_8_35 r0 *1 0,0
Xgf180mcu_fd_sc_mcu9t5v0__fill_8_35 VDD VSS gf180mcu_fd_sc_mcu9t5v0__fill_8
* cell instance gf180mcu_fd_sc_mcu9t5v0__fill_8_36 r0 *1 0,0
Xgf180mcu_fd_sc_mcu9t5v0__fill_8_36 VDD VSS gf180mcu_fd_sc_mcu9t5v0__fill_8
* cell instance gf180mcu_fd_sc_mcu9t5v0__fill_8_37 r0 *1 0,0
Xgf180mcu_fd_sc_mcu9t5v0__fill_8_37 VDD VSS gf180mcu_fd_sc_mcu9t5v0__fill_8
* cell instance gf180mcu_fd_sc_mcu9t5v0__fill_8_38 r0 *1 0,0
Xgf180mcu_fd_sc_mcu9t5v0__fill_8_38 VDD VSS gf180mcu_fd_sc_mcu9t5v0__fill_8
* cell instance gf180mcu_fd_sc_mcu9t5v0__fill_8_39 r0 *1 0,0
Xgf180mcu_fd_sc_mcu9t5v0__fill_8_39 VDD VSS gf180mcu_fd_sc_mcu9t5v0__fill_8
* cell instance gf180mcu_fd_sc_mcu9t5v0__fill_8_40 r0 *1 0,0
Xgf180mcu_fd_sc_mcu9t5v0__fill_8_40 VDD VSS gf180mcu_fd_sc_mcu9t5v0__fill_8
* cell instance gf180mcu_fd_sc_mcu9t5v0__fill_8_41 r0 *1 0,0
Xgf180mcu_fd_sc_mcu9t5v0__fill_8_41 VDD VSS gf180mcu_fd_sc_mcu9t5v0__fill_8
* cell instance gf180mcu_fd_sc_mcu9t5v0__fill_8_42 r0 *1 0,0
Xgf180mcu_fd_sc_mcu9t5v0__fill_8_42 VDD VSS gf180mcu_fd_sc_mcu9t5v0__fill_8
* cell instance gf180mcu_fd_sc_mcu9t5v0__fill_8_43 r0 *1 0,0
Xgf180mcu_fd_sc_mcu9t5v0__fill_8_43 VDD VSS gf180mcu_fd_sc_mcu9t5v0__fill_8
* cell instance gf180mcu_fd_sc_mcu9t5v0__fill_8_44 r0 *1 0,0
Xgf180mcu_fd_sc_mcu9t5v0__fill_8_44 VDD VSS gf180mcu_fd_sc_mcu9t5v0__fill_8
* cell instance gf180mcu_fd_sc_mcu9t5v0__fill_8_45 r0 *1 0,0
Xgf180mcu_fd_sc_mcu9t5v0__fill_8_45 VDD VSS gf180mcu_fd_sc_mcu9t5v0__fill_8
* cell instance gf180mcu_fd_sc_mcu9t5v0__fill_8_46 r0 *1 0,0
Xgf180mcu_fd_sc_mcu9t5v0__fill_8_46 VDD VSS gf180mcu_fd_sc_mcu9t5v0__fill_8
* cell instance gf180mcu_fd_sc_mcu9t5v0__fill_8_47 r0 *1 0,0
Xgf180mcu_fd_sc_mcu9t5v0__fill_8_47 VDD VSS gf180mcu_fd_sc_mcu9t5v0__fill_8
* cell instance gf180mcu_fd_sc_mcu9t5v0__fill_8_48 r0 *1 0,0
Xgf180mcu_fd_sc_mcu9t5v0__fill_8_48 VDD VSS gf180mcu_fd_sc_mcu9t5v0__fill_8
* cell instance gf180mcu_fd_sc_mcu9t5v0__fill_8_49 r0 *1 0,0
Xgf180mcu_fd_sc_mcu9t5v0__fill_8_49 VDD VSS gf180mcu_fd_sc_mcu9t5v0__fill_8
* cell instance gf180mcu_fd_sc_mcu9t5v0__fill_8_50 r0 *1 0,0
Xgf180mcu_fd_sc_mcu9t5v0__fill_8_50 VDD VSS gf180mcu_fd_sc_mcu9t5v0__fill_8
* cell instance gf180mcu_fd_sc_mcu9t5v0__fill_8_51 r0 *1 0,0
Xgf180mcu_fd_sc_mcu9t5v0__fill_8_51 VDD VSS gf180mcu_fd_sc_mcu9t5v0__fill_8
* cell instance gf180mcu_fd_sc_mcu9t5v0__fill_8_52 r0 *1 0,0
Xgf180mcu_fd_sc_mcu9t5v0__fill_8_52 VDD VSS gf180mcu_fd_sc_mcu9t5v0__fill_8
* cell instance gf180mcu_fd_sc_mcu9t5v0__fill_8_53 r0 *1 0,0
Xgf180mcu_fd_sc_mcu9t5v0__fill_8_53 VDD VSS gf180mcu_fd_sc_mcu9t5v0__fill_8
* cell instance gf180mcu_fd_sc_mcu9t5v0__fill_8_54 r0 *1 0,0
Xgf180mcu_fd_sc_mcu9t5v0__fill_8_54 VDD VSS gf180mcu_fd_sc_mcu9t5v0__fill_8
* cell instance gf180mcu_fd_sc_mcu9t5v0__fill_8_55 r0 *1 0,0
Xgf180mcu_fd_sc_mcu9t5v0__fill_8_55 VDD VSS gf180mcu_fd_sc_mcu9t5v0__fill_8
* cell instance gf180mcu_fd_sc_mcu9t5v0__fill_8_56 r0 *1 0,0
Xgf180mcu_fd_sc_mcu9t5v0__fill_8_56 VDD VSS gf180mcu_fd_sc_mcu9t5v0__fill_8
* cell instance gf180mcu_fd_sc_mcu9t5v0__fill_8_57 r0 *1 0,0
Xgf180mcu_fd_sc_mcu9t5v0__fill_8_57 VDD VSS gf180mcu_fd_sc_mcu9t5v0__fill_8
* cell instance gf180mcu_fd_sc_mcu9t5v0__fill_8_58 r0 *1 0,0
Xgf180mcu_fd_sc_mcu9t5v0__fill_8_58 VDD VSS gf180mcu_fd_sc_mcu9t5v0__fill_8
* cell instance gf180mcu_fd_sc_mcu9t5v0__fill_8_59 r0 *1 0,0
Xgf180mcu_fd_sc_mcu9t5v0__fill_8_59 VDD VSS gf180mcu_fd_sc_mcu9t5v0__fill_8
* cell instance gf180mcu_fd_sc_mcu9t5v0__fill_8_60 r0 *1 0,0
Xgf180mcu_fd_sc_mcu9t5v0__fill_8_60 VDD VSS gf180mcu_fd_sc_mcu9t5v0__fill_8
* cell instance gf180mcu_fd_sc_mcu9t5v0__fill_8_61 r0 *1 0,0
Xgf180mcu_fd_sc_mcu9t5v0__fill_8_61 VDD VSS gf180mcu_fd_sc_mcu9t5v0__fill_8
* cell instance gf180mcu_fd_sc_mcu9t5v0__fill_8_62 r0 *1 0,0
Xgf180mcu_fd_sc_mcu9t5v0__fill_8_62 VDD VSS gf180mcu_fd_sc_mcu9t5v0__fill_8
* cell instance gf180mcu_fd_sc_mcu9t5v0__fill_8_63 r0 *1 0,0
Xgf180mcu_fd_sc_mcu9t5v0__fill_8_63 VDD VSS gf180mcu_fd_sc_mcu9t5v0__fill_8
* cell instance gf180mcu_fd_sc_mcu9t5v0__fill_8_64 r0 *1 0,0
Xgf180mcu_fd_sc_mcu9t5v0__fill_8_64 VDD VSS gf180mcu_fd_sc_mcu9t5v0__fill_8
* cell instance gf180mcu_fd_sc_mcu9t5v0__fill_8_65 r0 *1 0,0
Xgf180mcu_fd_sc_mcu9t5v0__fill_8_65 VDD VSS gf180mcu_fd_sc_mcu9t5v0__fill_8
* cell instance gf180mcu_fd_sc_mcu9t5v0__fill_8_66 r0 *1 0,0
Xgf180mcu_fd_sc_mcu9t5v0__fill_8_66 VDD VSS gf180mcu_fd_sc_mcu9t5v0__fill_8
* cell instance gf180mcu_fd_sc_mcu9t5v0__fill_8_67 r0 *1 0,0
Xgf180mcu_fd_sc_mcu9t5v0__fill_8_67 VDD VSS gf180mcu_fd_sc_mcu9t5v0__fill_8
* cell instance gf180mcu_fd_sc_mcu9t5v0__fill_8_68 r0 *1 0,0
Xgf180mcu_fd_sc_mcu9t5v0__fill_8_68 VDD VSS gf180mcu_fd_sc_mcu9t5v0__fill_8
* cell instance gf180mcu_fd_sc_mcu9t5v0__fill_8_69 r0 *1 0,0
Xgf180mcu_fd_sc_mcu9t5v0__fill_8_69 VDD VSS gf180mcu_fd_sc_mcu9t5v0__fill_8
* cell instance gf180mcu_fd_sc_mcu9t5v0__fill_8_70 r0 *1 0,0
Xgf180mcu_fd_sc_mcu9t5v0__fill_8_70 VDD VSS gf180mcu_fd_sc_mcu9t5v0__fill_8
* cell instance gf180mcu_fd_sc_mcu9t5v0__fill_8_71 r0 *1 0,0
Xgf180mcu_fd_sc_mcu9t5v0__fill_8_71 VDD VSS gf180mcu_fd_sc_mcu9t5v0__fill_8
* cell instance gf180mcu_fd_sc_mcu9t5v0__fill_8_72 r0 *1 0,0
Xgf180mcu_fd_sc_mcu9t5v0__fill_8_72 VDD VSS gf180mcu_fd_sc_mcu9t5v0__fill_8
* cell instance gf180mcu_fd_sc_mcu9t5v0__fill_8_73 r0 *1 0,0
Xgf180mcu_fd_sc_mcu9t5v0__fill_8_73 VDD VSS gf180mcu_fd_sc_mcu9t5v0__fill_8
* cell instance gf180mcu_fd_sc_mcu9t5v0__fill_8_74 r0 *1 0,0
Xgf180mcu_fd_sc_mcu9t5v0__fill_8_74 VDD VSS gf180mcu_fd_sc_mcu9t5v0__fill_8
* cell instance gf180mcu_fd_sc_mcu9t5v0__fill_8_75 r0 *1 0,0
Xgf180mcu_fd_sc_mcu9t5v0__fill_8_75 VDD VSS gf180mcu_fd_sc_mcu9t5v0__fill_8
* cell instance gf180mcu_fd_sc_mcu9t5v0__fill_8_76 r0 *1 0,0
Xgf180mcu_fd_sc_mcu9t5v0__fill_8_76 VDD VSS gf180mcu_fd_sc_mcu9t5v0__fill_8
* cell instance gf180mcu_fd_sc_mcu9t5v0__fill_8_77 r0 *1 0,0
Xgf180mcu_fd_sc_mcu9t5v0__fill_8_77 VDD VSS gf180mcu_fd_sc_mcu9t5v0__fill_8
* cell instance gf180mcu_fd_sc_mcu9t5v0__fill_8_78 r0 *1 0,0
Xgf180mcu_fd_sc_mcu9t5v0__fill_8_78 VDD VSS gf180mcu_fd_sc_mcu9t5v0__fill_8
* cell instance gf180mcu_fd_sc_mcu9t5v0__fill_8_79 r0 *1 0,0
Xgf180mcu_fd_sc_mcu9t5v0__fill_8_79 VDD VSS gf180mcu_fd_sc_mcu9t5v0__fill_8
* cell instance gf180mcu_fd_sc_mcu9t5v0__fill_8_80 r0 *1 0,0
Xgf180mcu_fd_sc_mcu9t5v0__fill_8_80 VDD VSS gf180mcu_fd_sc_mcu9t5v0__fill_8
* cell instance gf180mcu_fd_sc_mcu9t5v0__fill_8_81 r0 *1 0,0
Xgf180mcu_fd_sc_mcu9t5v0__fill_8_81 VDD VSS gf180mcu_fd_sc_mcu9t5v0__fill_8
* cell instance gf180mcu_fd_sc_mcu9t5v0__fill_8_82 r0 *1 0,0
Xgf180mcu_fd_sc_mcu9t5v0__fill_8_82 VDD VSS gf180mcu_fd_sc_mcu9t5v0__fill_8
* cell instance gf180mcu_fd_sc_mcu9t5v0__fill_8_83 r0 *1 0,0
Xgf180mcu_fd_sc_mcu9t5v0__fill_8_83 VDD VSS gf180mcu_fd_sc_mcu9t5v0__fill_8
* cell instance gf180mcu_fd_sc_mcu9t5v0__fill_8_84 r0 *1 0,0
Xgf180mcu_fd_sc_mcu9t5v0__fill_8_84 VDD VSS gf180mcu_fd_sc_mcu9t5v0__fill_8
* cell instance gf180mcu_fd_sc_mcu9t5v0__fill_8_85 r0 *1 0,0
Xgf180mcu_fd_sc_mcu9t5v0__fill_8_85 VDD VSS gf180mcu_fd_sc_mcu9t5v0__fill_8
* cell instance gf180mcu_fd_sc_mcu9t5v0__fill_8_86 r0 *1 0,0
Xgf180mcu_fd_sc_mcu9t5v0__fill_8_86 VDD VSS gf180mcu_fd_sc_mcu9t5v0__fill_8
* cell instance gf180mcu_fd_sc_mcu9t5v0__fill_8_87 r0 *1 0,0
Xgf180mcu_fd_sc_mcu9t5v0__fill_8_87 VDD VSS gf180mcu_fd_sc_mcu9t5v0__fill_8
* cell instance gf180mcu_fd_sc_mcu9t5v0__fill_8_88 r0 *1 0,0
Xgf180mcu_fd_sc_mcu9t5v0__fill_8_88 VDD VSS gf180mcu_fd_sc_mcu9t5v0__fill_8
* cell instance gf180mcu_fd_sc_mcu9t5v0__fill_8_89 r0 *1 0,0
Xgf180mcu_fd_sc_mcu9t5v0__fill_8_89 VDD VSS gf180mcu_fd_sc_mcu9t5v0__fill_8
* cell instance gf180mcu_fd_sc_mcu9t5v0__fill_8_90 r0 *1 0,0
Xgf180mcu_fd_sc_mcu9t5v0__fill_8_90 VDD VSS gf180mcu_fd_sc_mcu9t5v0__fill_8
* cell instance gf180mcu_fd_sc_mcu9t5v0__fill_8_91 r0 *1 0,0
Xgf180mcu_fd_sc_mcu9t5v0__fill_8_91 VDD VSS gf180mcu_fd_sc_mcu9t5v0__fill_8
* cell instance gf180mcu_fd_sc_mcu9t5v0__fill_8_92 r0 *1 0,0
Xgf180mcu_fd_sc_mcu9t5v0__fill_8_92 VDD VSS gf180mcu_fd_sc_mcu9t5v0__fill_8
* cell instance gf180mcu_fd_sc_mcu9t5v0__fill_8_93 r0 *1 0,0
Xgf180mcu_fd_sc_mcu9t5v0__fill_8_93 VDD VSS gf180mcu_fd_sc_mcu9t5v0__fill_8
* cell instance gf180mcu_fd_sc_mcu9t5v0__fill_8_94 r0 *1 0,0
Xgf180mcu_fd_sc_mcu9t5v0__fill_8_94 VDD VSS gf180mcu_fd_sc_mcu9t5v0__fill_8
* cell instance gf180mcu_fd_sc_mcu9t5v0__fill_8_95 r0 *1 0,0
Xgf180mcu_fd_sc_mcu9t5v0__fill_8_95 VDD VSS gf180mcu_fd_sc_mcu9t5v0__fill_8
* cell instance gf180mcu_fd_sc_mcu9t5v0__fill_8_96 r0 *1 0,0
Xgf180mcu_fd_sc_mcu9t5v0__fill_8_96 VDD VSS gf180mcu_fd_sc_mcu9t5v0__fill_8
* cell instance gf180mcu_fd_sc_mcu9t5v0__fill_8_97 r0 *1 0,0
Xgf180mcu_fd_sc_mcu9t5v0__fill_8_97 VDD VSS gf180mcu_fd_sc_mcu9t5v0__fill_8
* cell instance gf180mcu_fd_sc_mcu9t5v0__fill_8_98 r0 *1 0,0
Xgf180mcu_fd_sc_mcu9t5v0__fill_8_98 VDD VSS gf180mcu_fd_sc_mcu9t5v0__fill_8
* cell instance gf180mcu_fd_sc_mcu9t5v0__fill_8_99 r0 *1 0,0
Xgf180mcu_fd_sc_mcu9t5v0__fill_8_99 VDD VSS gf180mcu_fd_sc_mcu9t5v0__fill_8
* cell instance gf180mcu_fd_sc_mcu9t5v0__fill_8_100 r0 *1 0,0
Xgf180mcu_fd_sc_mcu9t5v0__fill_8_100 VDD VSS gf180mcu_fd_sc_mcu9t5v0__fill_8
* cell instance gf180mcu_fd_sc_mcu9t5v0__fill_8_101 r0 *1 0,0
Xgf180mcu_fd_sc_mcu9t5v0__fill_8_101 VDD VSS gf180mcu_fd_sc_mcu9t5v0__fill_8
* cell instance gf180mcu_fd_sc_mcu9t5v0__fill_8_102 r0 *1 0,0
Xgf180mcu_fd_sc_mcu9t5v0__fill_8_102 VDD VSS gf180mcu_fd_sc_mcu9t5v0__fill_8
* cell instance gf180mcu_fd_sc_mcu9t5v0__fill_8_103 r0 *1 0,0
Xgf180mcu_fd_sc_mcu9t5v0__fill_8_103 VDD VSS gf180mcu_fd_sc_mcu9t5v0__fill_8
* cell instance gf180mcu_fd_sc_mcu9t5v0__fill_8_104 r0 *1 0,0
Xgf180mcu_fd_sc_mcu9t5v0__fill_8_104 VDD VSS gf180mcu_fd_sc_mcu9t5v0__fill_8
* cell instance gf180mcu_fd_sc_mcu9t5v0__fill_8_105 r0 *1 0,0
Xgf180mcu_fd_sc_mcu9t5v0__fill_8_105 VDD VSS gf180mcu_fd_sc_mcu9t5v0__fill_8
* cell instance gf180mcu_fd_sc_mcu9t5v0__fill_8_106 r0 *1 0,0
Xgf180mcu_fd_sc_mcu9t5v0__fill_8_106 VDD VSS gf180mcu_fd_sc_mcu9t5v0__fill_8
* cell instance gf180mcu_fd_sc_mcu9t5v0__fill_8_107 r0 *1 0,0
Xgf180mcu_fd_sc_mcu9t5v0__fill_8_107 VDD VSS gf180mcu_fd_sc_mcu9t5v0__fill_8
* cell instance gf180mcu_fd_sc_mcu9t5v0__fill_8_108 r0 *1 0,0
Xgf180mcu_fd_sc_mcu9t5v0__fill_8_108 VDD VSS gf180mcu_fd_sc_mcu9t5v0__fill_8
* cell instance gf180mcu_fd_sc_mcu9t5v0__fill_8_109 r0 *1 0,0
Xgf180mcu_fd_sc_mcu9t5v0__fill_8_109 VDD VSS gf180mcu_fd_sc_mcu9t5v0__fill_8
* cell instance gf180mcu_fd_sc_mcu9t5v0__fill_8_110 r0 *1 0,0
Xgf180mcu_fd_sc_mcu9t5v0__fill_8_110 VDD VSS gf180mcu_fd_sc_mcu9t5v0__fill_8
* cell instance gf180mcu_fd_sc_mcu9t5v0__fill_8_111 r0 *1 0,0
Xgf180mcu_fd_sc_mcu9t5v0__fill_8_111 VDD VSS gf180mcu_fd_sc_mcu9t5v0__fill_8
* cell instance gf180mcu_fd_sc_mcu9t5v0__fill_8_112 r0 *1 0,0
Xgf180mcu_fd_sc_mcu9t5v0__fill_8_112 VDD VSS gf180mcu_fd_sc_mcu9t5v0__fill_8
* cell instance gf180mcu_fd_sc_mcu9t5v0__fill_8_113 r0 *1 0,0
Xgf180mcu_fd_sc_mcu9t5v0__fill_8_113 VDD VSS gf180mcu_fd_sc_mcu9t5v0__fill_8
* cell instance gf180mcu_fd_sc_mcu9t5v0__fill_8_114 r0 *1 0,0
Xgf180mcu_fd_sc_mcu9t5v0__fill_8_114 VDD VSS gf180mcu_fd_sc_mcu9t5v0__fill_8
* cell instance gf180mcu_fd_sc_mcu9t5v0__fill_8_115 r0 *1 0,0
Xgf180mcu_fd_sc_mcu9t5v0__fill_8_115 VDD VSS gf180mcu_fd_sc_mcu9t5v0__fill_8
* cell instance gf180mcu_fd_sc_mcu9t5v0__fill_8_116 r0 *1 0,0
Xgf180mcu_fd_sc_mcu9t5v0__fill_8_116 VDD VSS gf180mcu_fd_sc_mcu9t5v0__fill_8
* cell instance gf180mcu_fd_sc_mcu9t5v0__fill_8_117 r0 *1 0,0
Xgf180mcu_fd_sc_mcu9t5v0__fill_8_117 VDD VSS gf180mcu_fd_sc_mcu9t5v0__fill_8
* cell instance gf180mcu_fd_sc_mcu9t5v0__fill_8_118 r0 *1 0,0
Xgf180mcu_fd_sc_mcu9t5v0__fill_8_118 VDD VSS gf180mcu_fd_sc_mcu9t5v0__fill_8
* cell instance gf180mcu_fd_sc_mcu9t5v0__fill_8_119 r0 *1 0,0
Xgf180mcu_fd_sc_mcu9t5v0__fill_8_119 VDD VSS gf180mcu_fd_sc_mcu9t5v0__fill_8
* cell instance gf180mcu_fd_sc_mcu9t5v0__filltie_0 r0 *1 0,0
Xgf180mcu_fd_sc_mcu9t5v0__filltie_0 VDD VSS gf180mcu_fd_sc_mcu9t5v0__filltie
* cell instance gf180mcu_fd_sc_mcu9t5v0__filltie_1 r0 *1 0,0
Xgf180mcu_fd_sc_mcu9t5v0__filltie_1 VDD VSS gf180mcu_fd_sc_mcu9t5v0__filltie
* cell instance gf180mcu_fd_sc_mcu9t5v0__filltie_2 r0 *1 0,0
Xgf180mcu_fd_sc_mcu9t5v0__filltie_2 VDD VSS gf180mcu_fd_sc_mcu9t5v0__filltie
* cell instance gf180mcu_fd_sc_mcu9t5v0__filltie_3 r0 *1 0,0
Xgf180mcu_fd_sc_mcu9t5v0__filltie_3 VDD VSS gf180mcu_fd_sc_mcu9t5v0__filltie
* cell instance gf180mcu_fd_sc_mcu9t5v0__filltie_4 r0 *1 0,0
Xgf180mcu_fd_sc_mcu9t5v0__filltie_4 VDD VSS gf180mcu_fd_sc_mcu9t5v0__filltie
* cell instance gf180mcu_fd_sc_mcu9t5v0__filltie_5 r0 *1 0,0
Xgf180mcu_fd_sc_mcu9t5v0__filltie_5 VDD VSS gf180mcu_fd_sc_mcu9t5v0__filltie
* cell instance gf180mcu_fd_sc_mcu9t5v0__filltie_6 r0 *1 0,0
Xgf180mcu_fd_sc_mcu9t5v0__filltie_6 VDD VSS gf180mcu_fd_sc_mcu9t5v0__filltie
* cell instance gf180mcu_fd_sc_mcu9t5v0__filltie_7 r0 *1 0,0
Xgf180mcu_fd_sc_mcu9t5v0__filltie_7 VDD VSS gf180mcu_fd_sc_mcu9t5v0__filltie
* cell instance gf180mcu_fd_sc_mcu9t5v0__filltie_8 r0 *1 0,0
Xgf180mcu_fd_sc_mcu9t5v0__filltie_8 VDD VSS gf180mcu_fd_sc_mcu9t5v0__filltie
* cell instance gf180mcu_fd_sc_mcu9t5v0__filltie_9 r0 *1 0,0
Xgf180mcu_fd_sc_mcu9t5v0__filltie_9 VDD VSS gf180mcu_fd_sc_mcu9t5v0__filltie
* cell instance gf180mcu_fd_sc_mcu9t5v0__filltie_10 r0 *1 0,0
Xgf180mcu_fd_sc_mcu9t5v0__filltie_10 VDD VSS gf180mcu_fd_sc_mcu9t5v0__filltie
* cell instance gf180mcu_fd_sc_mcu9t5v0__filltie_11 r0 *1 0,0
Xgf180mcu_fd_sc_mcu9t5v0__filltie_11 VDD VSS gf180mcu_fd_sc_mcu9t5v0__filltie
* cell instance gf180mcu_fd_sc_mcu9t5v0__filltie_12 r0 *1 0,0
Xgf180mcu_fd_sc_mcu9t5v0__filltie_12 VDD VSS gf180mcu_fd_sc_mcu9t5v0__filltie
* cell instance gf180mcu_fd_sc_mcu9t5v0__filltie_13 r0 *1 0,0
Xgf180mcu_fd_sc_mcu9t5v0__filltie_13 VDD VSS gf180mcu_fd_sc_mcu9t5v0__filltie
* cell instance gf180mcu_fd_sc_mcu9t5v0__filltie_14 r0 *1 0,0
Xgf180mcu_fd_sc_mcu9t5v0__filltie_14 VDD VSS gf180mcu_fd_sc_mcu9t5v0__filltie
* cell instance gf180mcu_fd_sc_mcu9t5v0__filltie_15 r0 *1 0,0
Xgf180mcu_fd_sc_mcu9t5v0__filltie_15 VDD VSS gf180mcu_fd_sc_mcu9t5v0__filltie
* cell instance gf180mcu_fd_sc_mcu9t5v0__filltie_16 r0 *1 0,0
Xgf180mcu_fd_sc_mcu9t5v0__filltie_16 VDD VSS gf180mcu_fd_sc_mcu9t5v0__filltie
* cell instance gf180mcu_fd_sc_mcu9t5v0__filltie_17 r0 *1 0,0
Xgf180mcu_fd_sc_mcu9t5v0__filltie_17 VDD VSS gf180mcu_fd_sc_mcu9t5v0__filltie
* cell instance gf180mcu_fd_sc_mcu9t5v0__inv_1_0 r0 *1 0,0
Xgf180mcu_fd_sc_mcu9t5v0__inv_1_0 u_eop_detector/se0_count[1] VDD VSS
+ u_eop_detector/_14_ gf180mcu_fd_sc_mcu9t5v0__inv_1
* cell instance gf180mcu_fd_sc_mcu9t5v0__inv_2_0 r0 *1 0,0
Xgf180mcu_fd_sc_mcu9t5v0__inv_2_0 u_destuffer/ones_run[0] VDD VSS
+ u_destuffer/_11_ gf180mcu_fd_sc_mcu9t5v0__inv_2
* cell instance gf180mcu_fd_sc_mcu9t5v0__inv_2_1 r0 *1 0,0
Xgf180mcu_fd_sc_mcu9t5v0__inv_2_1 dec_data_strobe VDD VSS u_destuffer/_08_
+ gf180mcu_fd_sc_mcu9t5v0__inv_2
* cell instance gf180mcu_fd_sc_mcu9t5v0__inv_2_2 r0 *1 0,0
Xgf180mcu_fd_sc_mcu9t5v0__inv_2_2 rxdp VDD VSS u_line_state/_2_
+ gf180mcu_fd_sc_mcu9t5v0__inv_2
* cell instance gf180mcu_fd_sc_mcu9t5v0__inv_2_3 r0 *1 0,0
Xgf180mcu_fd_sc_mcu9t5v0__inv_2_3 \_052_ VDD VSS \_053_
+ gf180mcu_fd_sc_mcu9t5v0__inv_2
* cell instance gf180mcu_fd_sc_mcu9t5v0__inv_3_0 r0 *1 0,0
Xgf180mcu_fd_sc_mcu9t5v0__inv_3_0 clknet_3_3__leaf_clk VDD VSS \$739
+ gf180mcu_fd_sc_mcu9t5v0__inv_3
* cell instance gf180mcu_fd_sc_mcu9t5v0__inv_3_1 r0 *1 0,0
Xgf180mcu_fd_sc_mcu9t5v0__inv_3_1 u_stuffer/run[0] VDD VSS u_stuffer/_03_
+ gf180mcu_fd_sc_mcu9t5v0__inv_3
* cell instance gf180mcu_fd_sc_mcu9t5v0__inv_4_0 r0 *1 0,0
Xgf180mcu_fd_sc_mcu9t5v0__inv_4_0 clknet_3_0__leaf_clk VDD VSS \$277
+ gf180mcu_fd_sc_mcu9t5v0__inv_4
* cell instance gf180mcu_fd_sc_mcu9t5v0__inv_4_1 r0 *1 0,0
Xgf180mcu_fd_sc_mcu9t5v0__inv_4_1 clknet_3_1__leaf_clk VDD VSS \$212
+ gf180mcu_fd_sc_mcu9t5v0__inv_4
* cell instance gf180mcu_fd_sc_mcu9t5v0__inv_4_2 r0 *1 0,0
Xgf180mcu_fd_sc_mcu9t5v0__inv_4_2 clknet_3_6__leaf_clk VDD VSS \$595
+ gf180mcu_fd_sc_mcu9t5v0__inv_4
* cell instance gf180mcu_fd_sc_mcu9t5v0__inv_4_3 r0 *1 0,0
Xgf180mcu_fd_sc_mcu9t5v0__inv_4_3 clknet_3_7__leaf_clk VDD VSS \$742
+ gf180mcu_fd_sc_mcu9t5v0__inv_4
* cell instance gf180mcu_fd_sc_mcu9t5v0__inv_8_0 r0 *1 0,0
Xgf180mcu_fd_sc_mcu9t5v0__inv_8_0 clknet_3_4__leaf_clk VDD VSS \$252
+ gf180mcu_fd_sc_mcu9t5v0__inv_8
* cell instance gf180mcu_fd_sc_mcu9t5v0__mux2_1_0 r0 *1 0,0
Xgf180mcu_fd_sc_mcu9t5v0__mux2_1_0 dec_bit_level u_decoder/prev_level
+ u_decoder/_04_ VDD VSS u_decoder/_01_ gf180mcu_fd_sc_mcu9t5v0__mux2_1
* cell instance gf180mcu_fd_sc_mcu9t5v0__mux2_1_1 r0 *1 0,0
Xgf180mcu_fd_sc_mcu9t5v0__mux2_1_1 \_063_ stuff_bit_out \_076_ VDD VSS \_013_
+ gf180mcu_fd_sc_mcu9t5v0__mux2_1
* cell instance gf180mcu_fd_sc_mcu9t5v0__mux2_1_2 r0 *1 0,0
Xgf180mcu_fd_sc_mcu9t5v0__mux2_1_2 tx_state[4] stuff_consume tx_state[2] VDD
+ VSS \_133_ gf180mcu_fd_sc_mcu9t5v0__mux2_1
* cell instance gf180mcu_fd_sc_mcu9t5v0__mux2_1_3 r0 *1 0,0
Xgf180mcu_fd_sc_mcu9t5v0__mux2_1_3 tx_state[4] TxValid tx_state[0] VDD VSS
+ \_119_ gf180mcu_fd_sc_mcu9t5v0__mux2_1
* cell instance gf180mcu_fd_sc_mcu9t5v0__mux2_2_0 r0 *1 0,0
Xgf180mcu_fd_sc_mcu9t5v0__mux2_2_0 DataIn[0] rx_shift[1] \_096_ VDD VSS \_044_
+ gf180mcu_fd_sc_mcu9t5v0__mux2_2
* cell instance gf180mcu_fd_sc_mcu9t5v0__mux2_2_1 r0 *1 0,0
Xgf180mcu_fd_sc_mcu9t5v0__mux2_2_1 DataIn[1] rx_shift[2] \_096_ VDD VSS \_043_
+ gf180mcu_fd_sc_mcu9t5v0__mux2_2
* cell instance gf180mcu_fd_sc_mcu9t5v0__mux2_2_2 r0 *1 0,0
Xgf180mcu_fd_sc_mcu9t5v0__mux2_2_2 DataIn[2] rx_shift[3] \_096_ VDD VSS \_042_
+ gf180mcu_fd_sc_mcu9t5v0__mux2_2
* cell instance gf180mcu_fd_sc_mcu9t5v0__mux2_2_3 r0 *1 0,0
Xgf180mcu_fd_sc_mcu9t5v0__mux2_2_3 DataIn[3] rx_shift[4] \_096_ VDD VSS \_039_
+ gf180mcu_fd_sc_mcu9t5v0__mux2_2
* cell instance gf180mcu_fd_sc_mcu9t5v0__mux2_2_4 r0 *1 0,0
Xgf180mcu_fd_sc_mcu9t5v0__mux2_2_4 u_decoder/_03_ dec_data_bit u_decoder/_04_
+ VDD VSS u_decoder/_02_ gf180mcu_fd_sc_mcu9t5v0__mux2_2
* cell instance gf180mcu_fd_sc_mcu9t5v0__mux2_2_5 r0 *1 0,0
Xgf180mcu_fd_sc_mcu9t5v0__mux2_2_5 rx_out_bit dec_data_bit u_destuffer/_00_ VDD
+ VSS u_destuffer/_03_ gf180mcu_fd_sc_mcu9t5v0__mux2_2
* cell instance gf180mcu_fd_sc_mcu9t5v0__mux2_2_6 r0 *1 0,0
Xgf180mcu_fd_sc_mcu9t5v0__mux2_2_6 DataIn[4] rx_shift[5] \_096_ VDD VSS \_037_
+ gf180mcu_fd_sc_mcu9t5v0__mux2_2
* cell instance gf180mcu_fd_sc_mcu9t5v0__mux2_2_7 r0 *1 0,0
Xgf180mcu_fd_sc_mcu9t5v0__mux2_2_7 DataIn[6] rx_shift[7] \_096_ VDD VSS \_034_
+ gf180mcu_fd_sc_mcu9t5v0__mux2_2
* cell instance gf180mcu_fd_sc_mcu9t5v0__mux2_2_8 r0 *1 0,0
Xgf180mcu_fd_sc_mcu9t5v0__mux2_2_8 DataIn[5] rx_shift[6] \_096_ VDD VSS \_035_
+ gf180mcu_fd_sc_mcu9t5v0__mux2_2
* cell instance gf180mcu_fd_sc_mcu9t5v0__mux2_2_9 r0 *1 0,0
Xgf180mcu_fd_sc_mcu9t5v0__mux2_2_9 DataIn[7] rx_out_bit \_096_ VDD VSS \_016_
+ gf180mcu_fd_sc_mcu9t5v0__mux2_2
* cell instance gf180mcu_fd_sc_mcu9t5v0__mux2_2_10 r0 *1 0,0
Xgf180mcu_fd_sc_mcu9t5v0__mux2_2_10 nrzi_level u_encoder/_2_ \_011_ VDD VSS
+ u_encoder/_0_ gf180mcu_fd_sc_mcu9t5v0__mux2_2
* cell instance gf180mcu_fd_sc_mcu9t5v0__mux4_1_0 r0 *1 0,0
Xgf180mcu_fd_sc_mcu9t5v0__mux4_1_0 byte_reg[0] byte_reg[1] byte_reg[4]
+ byte_reg[5] byte_idx[0] byte_idx[2] VDD VSS \_081_
+ gf180mcu_fd_sc_mcu9t5v0__mux4_1
* cell instance gf180mcu_fd_sc_mcu9t5v0__mux4_1_1 r0 *1 0,0
Xgf180mcu_fd_sc_mcu9t5v0__mux4_1_1 byte_reg[2] byte_reg[3] byte_reg[6]
+ byte_reg[7] byte_idx[0] byte_idx[2] VDD VSS \_078_
+ gf180mcu_fd_sc_mcu9t5v0__mux4_1
* cell instance gf180mcu_fd_sc_mcu9t5v0__nand2_1_0 r0 *1 0,0
Xgf180mcu_fd_sc_mcu9t5v0__nand2_1_0 rx_shift[2] \_086_ VDD VSS \_118_
+ gf180mcu_fd_sc_mcu9t5v0__nand2_1
* cell instance gf180mcu_fd_sc_mcu9t5v0__nand2_1_1 r0 *1 0,0
Xgf180mcu_fd_sc_mcu9t5v0__nand2_1_1 rx_shift[2] \_084_ VDD VSS \_115_
+ gf180mcu_fd_sc_mcu9t5v0__nand2_1
* cell instance gf180mcu_fd_sc_mcu9t5v0__nand2_1_2 r0 *1 0,0
Xgf180mcu_fd_sc_mcu9t5v0__nand2_1_2 rx_shift[1] \_084_ VDD VSS \_117_
+ gf180mcu_fd_sc_mcu9t5v0__nand2_1
* cell instance gf180mcu_fd_sc_mcu9t5v0__nand2_1_3 r0 *1 0,0
Xgf180mcu_fd_sc_mcu9t5v0__nand2_1_3 rx_shift[3] \_086_ VDD VSS \_116_
+ gf180mcu_fd_sc_mcu9t5v0__nand2_1
* cell instance gf180mcu_fd_sc_mcu9t5v0__nand2_1_4 r0 *1 0,0
Xgf180mcu_fd_sc_mcu9t5v0__nand2_1_4 rx_shift[3] \_084_ VDD VSS \_113_
+ gf180mcu_fd_sc_mcu9t5v0__nand2_1
* cell instance gf180mcu_fd_sc_mcu9t5v0__nand2_1_5 r0 *1 0,0
Xgf180mcu_fd_sc_mcu9t5v0__nand2_1_5 rx_shift[4] \_086_ VDD VSS \_114_
+ gf180mcu_fd_sc_mcu9t5v0__nand2_1
* cell instance gf180mcu_fd_sc_mcu9t5v0__nand2_1_6 r0 *1 0,0
Xgf180mcu_fd_sc_mcu9t5v0__nand2_1_6 rx_shift[4] \_084_ VDD VSS \_111_
+ gf180mcu_fd_sc_mcu9t5v0__nand2_1
* cell instance gf180mcu_fd_sc_mcu9t5v0__nand2_1_7 r0 *1 0,0
Xgf180mcu_fd_sc_mcu9t5v0__nand2_1_7 rx_shift[5] \_086_ VDD VSS \_112_
+ gf180mcu_fd_sc_mcu9t5v0__nand2_1
* cell instance gf180mcu_fd_sc_mcu9t5v0__nand2_1_8 r0 *1 0,0
Xgf180mcu_fd_sc_mcu9t5v0__nand2_1_8 rx_shift[7] \_084_ VDD VSS \_103_
+ gf180mcu_fd_sc_mcu9t5v0__nand2_1
* cell instance gf180mcu_fd_sc_mcu9t5v0__nand2_1_9 r0 *1 0,0
Xgf180mcu_fd_sc_mcu9t5v0__nand2_1_9 rx_shift[5] \_084_ VDD VSS \_085_
+ gf180mcu_fd_sc_mcu9t5v0__nand2_1
* cell instance gf180mcu_fd_sc_mcu9t5v0__nand2_1_10 r0 *1 0,0
Xgf180mcu_fd_sc_mcu9t5v0__nand2_1_10 rx_bit_valid rx_assembly_en VDD VSS \_084_
+ gf180mcu_fd_sc_mcu9t5v0__nand2_1
* cell instance gf180mcu_fd_sc_mcu9t5v0__nand2_1_11 r0 *1 0,0
Xgf180mcu_fd_sc_mcu9t5v0__nand2_1_11 rx_shift[7] \_086_ VDD VSS \_147_
+ gf180mcu_fd_sc_mcu9t5v0__nand2_1
* cell instance gf180mcu_fd_sc_mcu9t5v0__nand2_1_12 r0 *1 0,0
Xgf180mcu_fd_sc_mcu9t5v0__nand2_1_12 rx_shift[6] \_086_ VDD VSS \_088_
+ gf180mcu_fd_sc_mcu9t5v0__nand2_1
* cell instance gf180mcu_fd_sc_mcu9t5v0__nand2_1_13 r0 *1 0,0
Xgf180mcu_fd_sc_mcu9t5v0__nand2_1_13 rx_shift[6] \_084_ VDD VSS \_146_
+ gf180mcu_fd_sc_mcu9t5v0__nand2_1
* cell instance gf180mcu_fd_sc_mcu9t5v0__nand2_1_14 r0 *1 0,0
Xgf180mcu_fd_sc_mcu9t5v0__nand2_1_14 rx_out_bit \_086_ VDD VSS \_104_
+ gf180mcu_fd_sc_mcu9t5v0__nand2_1
* cell instance gf180mcu_fd_sc_mcu9t5v0__nand2_1_15 r0 *1 0,0
Xgf180mcu_fd_sc_mcu9t5v0__nand2_1_15 u_eop_detector/se0_count[1]
+ u_eop_detector/_10_ VDD VSS u_eop_detector/_20_
+ gf180mcu_fd_sc_mcu9t5v0__nand2_1
* cell instance gf180mcu_fd_sc_mcu9t5v0__nand2_1_16 r0 *1 0,0
Xgf180mcu_fd_sc_mcu9t5v0__nand2_1_16 \_053_ u_eop_detector/_08_ VDD VSS
+ u_eop_detector/_09_ gf180mcu_fd_sc_mcu9t5v0__nand2_1
* cell instance gf180mcu_fd_sc_mcu9t5v0__nand2_1_17 r0 *1 0,0
Xgf180mcu_fd_sc_mcu9t5v0__nand2_1_17 u_line_state/_2_ \_053_ VDD VSS
+ u_line_state/_0_ gf180mcu_fd_sc_mcu9t5v0__nand2_1
* cell instance gf180mcu_fd_sc_mcu9t5v0__nand2_1_18 r0 *1 0,0
Xgf180mcu_fd_sc_mcu9t5v0__nand2_1_18 u_eop_detector/_17_
+ u_eop_detector/se0_count[0] VDD VSS u_eop_detector/_18_
+ gf180mcu_fd_sc_mcu9t5v0__nand2_1
* cell instance gf180mcu_fd_sc_mcu9t5v0__nand2_1_19 r0 *1 0,0
Xgf180mcu_fd_sc_mcu9t5v0__nand2_1_19 \_068_ \_076_ VDD VSS \_011_
+ gf180mcu_fd_sc_mcu9t5v0__nand2_1
* cell instance gf180mcu_fd_sc_mcu9t5v0__nand2_1_20 r0 *1 0,0
Xgf180mcu_fd_sc_mcu9t5v0__nand2_1_20 tx_state[6] \_053_ VDD VSS \_058_
+ gf180mcu_fd_sc_mcu9t5v0__nand2_1
* cell instance gf180mcu_fd_sc_mcu9t5v0__nand2_1_21 r0 *1 0,0
Xgf180mcu_fd_sc_mcu9t5v0__nand2_1_21 stuff_consume \_053_ VDD VSS \_057_
+ gf180mcu_fd_sc_mcu9t5v0__nand2_1
* cell instance gf180mcu_fd_sc_mcu9t5v0__nand2_1_22 r0 *1 0,0
Xgf180mcu_fd_sc_mcu9t5v0__nand2_1_22 \_080_ \_081_ VDD VSS \_082_
+ gf180mcu_fd_sc_mcu9t5v0__nand2_1
* cell instance gf180mcu_fd_sc_mcu9t5v0__nand2_1_23 r0 *1 0,0
Xgf180mcu_fd_sc_mcu9t5v0__nand2_1_23 first_byte tx_state[2] VDD VSS \_083_
+ gf180mcu_fd_sc_mcu9t5v0__nand2_1
* cell instance gf180mcu_fd_sc_mcu9t5v0__nand2_1_24 r0 *1 0,0
Xgf180mcu_fd_sc_mcu9t5v0__nand2_1_24 tx_state[2] TxValid VDD VSS \_091_
+ gf180mcu_fd_sc_mcu9t5v0__nand2_1
* cell instance gf180mcu_fd_sc_mcu9t5v0__nand2_1_25 r0 *1 0,0
Xgf180mcu_fd_sc_mcu9t5v0__nand2_1_25 byte_idx[1] \_078_ VDD VSS \_079_
+ gf180mcu_fd_sc_mcu9t5v0__nand2_1
* cell instance gf180mcu_fd_sc_mcu9t5v0__nand2_1_26 r0 *1 0,0
Xgf180mcu_fd_sc_mcu9t5v0__nand2_1_26 tx_state[4] \_063_ VDD VSS \_073_
+ gf180mcu_fd_sc_mcu9t5v0__nand2_1
* cell instance gf180mcu_fd_sc_mcu9t5v0__nand2_2_0 r0 *1 0,0
Xgf180mcu_fd_sc_mcu9t5v0__nand2_2_0 rx_receiving \_053_ VDD VSS \_089_
+ gf180mcu_fd_sc_mcu9t5v0__nand2_2
* cell instance gf180mcu_fd_sc_mcu9t5v0__nand2_2_1 r0 *1 0,0
Xgf180mcu_fd_sc_mcu9t5v0__nand2_2_1 rst_n \_051_ VDD VSS \_052_
+ gf180mcu_fd_sc_mcu9t5v0__nand2_2
* cell instance gf180mcu_fd_sc_mcu9t5v0__nand2_2_2 r0 *1 0,0
Xgf180mcu_fd_sc_mcu9t5v0__nand2_2_2 u_stuffer/run[0] tx_body_active VDD VSS
+ u_stuffer/_10_ gf180mcu_fd_sc_mcu9t5v0__nand2_2
* cell instance gf180mcu_fd_sc_mcu9t5v0__nand2_2_3 r0 *1 0,0
Xgf180mcu_fd_sc_mcu9t5v0__nand2_2_3 TxValid tx_state[0] VDD VSS \_061_
+ gf180mcu_fd_sc_mcu9t5v0__nand2_2
* cell instance gf180mcu_fd_sc_mcu9t5v0__nand2_4_0 r0 *1 0,0
Xgf180mcu_fd_sc_mcu9t5v0__nand2_4_0 u_destuffer/ones_run[1]
+ u_destuffer/ones_run[2] VDD VSS u_destuffer/_06_
+ gf180mcu_fd_sc_mcu9t5v0__nand2_4
* cell instance gf180mcu_fd_sc_mcu9t5v0__nand2_4_1 r0 *1 0,0
Xgf180mcu_fd_sc_mcu9t5v0__nand2_4_1 dec_data_strobe dec_data_bit VDD VSS
+ u_sync_detector/_07_ gf180mcu_fd_sc_mcu9t5v0__nand2_4
* cell instance gf180mcu_fd_sc_mcu9t5v0__nand2_4_2 r0 *1 0,0
Xgf180mcu_fd_sc_mcu9t5v0__nand2_4_2 dec_bit_strobe dec_bit_strobe VDD VSS
+ u_decoder/_04_ gf180mcu_fd_sc_mcu9t5v0__nand2_4
* cell instance gf180mcu_fd_sc_mcu9t5v0__nand3_1_0 r0 *1 0,0
Xgf180mcu_fd_sc_mcu9t5v0__nand3_1_0 u_eop_detector/se0_count[3]
+ u_eop_detector/se0_count[2] u_eop_detector/_15_ VDD VSS u_eop_detector/_23_
+ gf180mcu_fd_sc_mcu9t5v0__nand3_1
* cell instance gf180mcu_fd_sc_mcu9t5v0__nand3_1_1 r0 *1 0,0
Xgf180mcu_fd_sc_mcu9t5v0__nand3_1_1 u_stuffer/run[2] \_012_ u_stuffer/_04_ VDD
+ VSS u_stuffer/_05_ gf180mcu_fd_sc_mcu9t5v0__nand3_1
* cell instance gf180mcu_fd_sc_mcu9t5v0__nand3_1_2 r0 *1 0,0
Xgf180mcu_fd_sc_mcu9t5v0__nand3_1_2 u_stuffer/_07_ \_012_ tx_body_active VDD
+ VSS u_stuffer/_08_ gf180mcu_fd_sc_mcu9t5v0__nand3_1
* cell instance gf180mcu_fd_sc_mcu9t5v0__nand3_1_3 r0 *1 0,0
Xgf180mcu_fd_sc_mcu9t5v0__nand3_1_3 byte_idx[0] byte_idx[1] byte_idx[2] VDD VSS
+ \_136_ gf180mcu_fd_sc_mcu9t5v0__nand3_1
* cell instance gf180mcu_fd_sc_mcu9t5v0__nand3_2_0 r0 *1 0,0
Xgf180mcu_fd_sc_mcu9t5v0__nand3_2_0 \_012_ u_stuffer/_04_ stuff_consume VDD VSS
+ u_stuffer/_09_ gf180mcu_fd_sc_mcu9t5v0__nand3_2
* cell instance gf180mcu_fd_sc_mcu9t5v0__nand3_2_1 r0 *1 0,0
Xgf180mcu_fd_sc_mcu9t5v0__nand3_2_1 u_stuffer/run[1] u_stuffer/run[0]
+ tx_body_active VDD VSS u_stuffer/_12_ gf180mcu_fd_sc_mcu9t5v0__nand3_2
* cell instance gf180mcu_fd_sc_mcu9t5v0__nand3_4_0 r0 *1 0,0
Xgf180mcu_fd_sc_mcu9t5v0__nand3_4_0 u_sync_detector/match[0]
+ u_sync_detector/match[1] u_sync_detector/match[2] VDD VSS
+ u_sync_detector/_06_ gf180mcu_fd_sc_mcu9t5v0__nand3_4
* cell instance gf180mcu_fd_sc_mcu9t5v0__nand3_4_1 r0 *1 0,0
Xgf180mcu_fd_sc_mcu9t5v0__nand3_4_1 \_010_ \_053_ u_sync_detector/_07_ VDD VSS
+ u_sync_detector/_09_ gf180mcu_fd_sc_mcu9t5v0__nand3_4
* cell instance gf180mcu_fd_sc_mcu9t5v0__nand4_1_0 r0 *1 0,0
Xgf180mcu_fd_sc_mcu9t5v0__nand4_1_0 tx_state[2] stuff_consume \_056_ \_064_ VDD
+ VSS \_143_ gf180mcu_fd_sc_mcu9t5v0__nand4_1
* cell instance gf180mcu_fd_sc_mcu9t5v0__nand4_4_0 r0 *1 0,0
Xgf180mcu_fd_sc_mcu9t5v0__nand4_4_0 u_stuffer/run[1] u_stuffer/_03_
+ u_stuffer/run[2] u_stuffer/_04_ VDD VSS stuff_consume
+ gf180mcu_fd_sc_mcu9t5v0__nand4_4
* cell instance gf180mcu_fd_sc_mcu9t5v0__nand4_4_1 r0 *1 0,0
Xgf180mcu_fd_sc_mcu9t5v0__nand4_4_1 byte_idx[0] byte_idx[1] byte_idx[2]
+ tx_state[2] VDD VSS \_055_ gf180mcu_fd_sc_mcu9t5v0__nand4_4
* cell instance gf180mcu_fd_sc_mcu9t5v0__nand4_4_2 r0 *1 0,0
Xgf180mcu_fd_sc_mcu9t5v0__nand4_4_2 byte_idx[0] byte_idx[1] byte_idx[2]
+ stuff_consume VDD VSS \_074_ gf180mcu_fd_sc_mcu9t5v0__nand4_4
* cell instance gf180mcu_fd_sc_mcu9t5v0__nor2_1_0 r0 *1 0,0
Xgf180mcu_fd_sc_mcu9t5v0__nor2_1_0 \_089_ \_127_ VDD VSS \_033_
+ gf180mcu_fd_sc_mcu9t5v0__nor2_1
* cell instance gf180mcu_fd_sc_mcu9t5v0__nor2_1_1 r0 *1 0,0
Xgf180mcu_fd_sc_mcu9t5v0__nor2_1_1 u_destuffer/_10_ u_destuffer/_14_ VDD VSS
+ u_destuffer/_04_ gf180mcu_fd_sc_mcu9t5v0__nor2_1
* cell instance gf180mcu_fd_sc_mcu9t5v0__nor2_1_2 r0 *1 0,0
Xgf180mcu_fd_sc_mcu9t5v0__nor2_1_2 u_destuffer/_12_ u_destuffer/_15_ VDD VSS
+ u_destuffer/_05_ gf180mcu_fd_sc_mcu9t5v0__nor2_1
* cell instance gf180mcu_fd_sc_mcu9t5v0__nor2_1_3 r0 *1 0,0
Xgf180mcu_fd_sc_mcu9t5v0__nor2_1_3 u_sync_detector/match[1]
+ u_sync_detector/_13_ VDD VSS u_sync_detector/_14_
+ gf180mcu_fd_sc_mcu9t5v0__nor2_1
* cell instance gf180mcu_fd_sc_mcu9t5v0__nor2_1_4 r0 *1 0,0
Xgf180mcu_fd_sc_mcu9t5v0__nor2_1_4 u_sync_detector/match[2]
+ u_sync_detector/_10_ VDD VSS u_sync_detector/_12_
+ gf180mcu_fd_sc_mcu9t5v0__nor2_1
* cell instance gf180mcu_fd_sc_mcu9t5v0__nor2_1_5 r0 *1 0,0
Xgf180mcu_fd_sc_mcu9t5v0__nor2_1_5 u_sync_detector/match[0] dec_data_strobe VDD
+ VSS u_sync_detector/_15_ gf180mcu_fd_sc_mcu9t5v0__nor2_1
* cell instance gf180mcu_fd_sc_mcu9t5v0__nor2_1_6 r0 *1 0,0
Xgf180mcu_fd_sc_mcu9t5v0__nor2_1_6 u_eop_detector/_09_ u_eop_detector/_13_ VDD
+ VSS u_eop_detector/_00_ gf180mcu_fd_sc_mcu9t5v0__nor2_1
* cell instance gf180mcu_fd_sc_mcu9t5v0__nor2_1_7 r0 *1 0,0
Xgf180mcu_fd_sc_mcu9t5v0__nor2_1_7 \_067_ line_state[1] VDD VSS dec_bit_level
+ gf180mcu_fd_sc_mcu9t5v0__nor2_1
* cell instance gf180mcu_fd_sc_mcu9t5v0__nor2_1_8 r0 *1 0,0
Xgf180mcu_fd_sc_mcu9t5v0__nor2_1_8 line_state[0] line_state[1] VDD VSS
+ u_eop_detector/_08_ gf180mcu_fd_sc_mcu9t5v0__nor2_1
* cell instance gf180mcu_fd_sc_mcu9t5v0__nor2_1_9 r0 *1 0,0
Xgf180mcu_fd_sc_mcu9t5v0__nor2_1_9 u_eop_detector/_17_ u_eop_detector/_09_ VDD
+ VSS u_eop_detector/_06_ gf180mcu_fd_sc_mcu9t5v0__nor2_1
* cell instance gf180mcu_fd_sc_mcu9t5v0__nor2_1_10 r0 *1 0,0
Xgf180mcu_fd_sc_mcu9t5v0__nor2_1_10 \_071_ \_070_ VDD VSS txdp
+ gf180mcu_fd_sc_mcu9t5v0__nor2_1
* cell instance gf180mcu_fd_sc_mcu9t5v0__nor2_1_11 r0 *1 0,0
Xgf180mcu_fd_sc_mcu9t5v0__nor2_1_11 \_077_ OpMode[0] VDD VSS raw_mode
+ gf180mcu_fd_sc_mcu9t5v0__nor2_1
* cell instance gf180mcu_fd_sc_mcu9t5v0__nor2_1_12 r0 *1 0,0
Xgf180mcu_fd_sc_mcu9t5v0__nor2_1_12 byte_reg[4] \_092_ VDD VSS \_100_
+ gf180mcu_fd_sc_mcu9t5v0__nor2_1
* cell instance gf180mcu_fd_sc_mcu9t5v0__nor2_1_13 r0 *1 0,0
Xgf180mcu_fd_sc_mcu9t5v0__nor2_1_13 tx_state[4] entering_sync VDD VSS \_076_
+ gf180mcu_fd_sc_mcu9t5v0__nor2_1
* cell instance gf180mcu_fd_sc_mcu9t5v0__nor2_1_14 r0 *1 0,0
Xgf180mcu_fd_sc_mcu9t5v0__nor2_1_14 tx_state[2] tx_state[6] VDD VSS \_068_
+ gf180mcu_fd_sc_mcu9t5v0__nor2_1
* cell instance gf180mcu_fd_sc_mcu9t5v0__nor2_1_15 r0 *1 0,0
Xgf180mcu_fd_sc_mcu9t5v0__nor2_1_15 byte_reg[5] \_092_ VDD VSS \_098_
+ gf180mcu_fd_sc_mcu9t5v0__nor2_1
* cell instance gf180mcu_fd_sc_mcu9t5v0__nor2_1_16 r0 *1 0,0
Xgf180mcu_fd_sc_mcu9t5v0__nor2_1_16 byte_reg[1] \_092_ VDD VSS \_108_
+ gf180mcu_fd_sc_mcu9t5v0__nor2_1
* cell instance gf180mcu_fd_sc_mcu9t5v0__nor2_1_17 r0 *1 0,0
Xgf180mcu_fd_sc_mcu9t5v0__nor2_1_17 byte_reg[0] \_092_ VDD VSS \_110_
+ gf180mcu_fd_sc_mcu9t5v0__nor2_1
* cell instance gf180mcu_fd_sc_mcu9t5v0__nor2_1_18 r0 *1 0,0
Xgf180mcu_fd_sc_mcu9t5v0__nor2_1_18 byte_reg[6] \_092_ VDD VSS \_094_
+ gf180mcu_fd_sc_mcu9t5v0__nor2_1
* cell instance gf180mcu_fd_sc_mcu9t5v0__nor2_1_19 r0 *1 0,0
Xgf180mcu_fd_sc_mcu9t5v0__nor2_1_19 byte_reg[7] \_092_ VDD VSS \_130_
+ gf180mcu_fd_sc_mcu9t5v0__nor2_1
* cell instance gf180mcu_fd_sc_mcu9t5v0__nor2_1_20 r0 *1 0,0
Xgf180mcu_fd_sc_mcu9t5v0__nor2_1_20 byte_reg[3] \_092_ VDD VSS \_102_
+ gf180mcu_fd_sc_mcu9t5v0__nor2_1
* cell instance gf180mcu_fd_sc_mcu9t5v0__nor2_1_21 r0 *1 0,0
Xgf180mcu_fd_sc_mcu9t5v0__nor2_1_21 byte_reg[2] \_092_ VDD VSS \_106_
+ gf180mcu_fd_sc_mcu9t5v0__nor2_1
* cell instance gf180mcu_fd_sc_mcu9t5v0__nor2_1_22 r0 *1 0,0
Xgf180mcu_fd_sc_mcu9t5v0__nor2_1_22 sync_idx[0] \_119_ VDD VSS \_126_
+ gf180mcu_fd_sc_mcu9t5v0__nor2_1
* cell instance gf180mcu_fd_sc_mcu9t5v0__nor2_1_23 r0 *1 0,0
Xgf180mcu_fd_sc_mcu9t5v0__nor2_1_23 \_134_ \_141_ VDD VSS \_142_
+ gf180mcu_fd_sc_mcu9t5v0__nor2_1
* cell instance gf180mcu_fd_sc_mcu9t5v0__nor2_1_24 r0 *1 0,0
Xgf180mcu_fd_sc_mcu9t5v0__nor2_1_24 \_132_ \_134_ VDD VSS \_144_
+ gf180mcu_fd_sc_mcu9t5v0__nor2_1
* cell instance gf180mcu_fd_sc_mcu9t5v0__nor2_2_0 r0 *1 0,0
Xgf180mcu_fd_sc_mcu9t5v0__nor2_2_0 u_destuffer/_10_ u_destuffer/_13_ VDD VSS
+ u_destuffer/_02_ gf180mcu_fd_sc_mcu9t5v0__nor2_2
* cell instance gf180mcu_fd_sc_mcu9t5v0__nor2_2_1 r0 *1 0,0
Xgf180mcu_fd_sc_mcu9t5v0__nor2_2_1 u_destuffer/ones_run[0] u_destuffer/_06_ VDD
+ VSS u_destuffer/_07_ gf180mcu_fd_sc_mcu9t5v0__nor2_2
* cell instance gf180mcu_fd_sc_mcu9t5v0__nor2_2_2 r0 *1 0,0
Xgf180mcu_fd_sc_mcu9t5v0__nor2_2_2 u_eop_detector/_09_ u_eop_detector/_16_ VDD
+ VSS u_eop_detector/_01_ gf180mcu_fd_sc_mcu9t5v0__nor2_2
* cell instance gf180mcu_fd_sc_mcu9t5v0__nor2_4_0 r0 *1 0,0
Xgf180mcu_fd_sc_mcu9t5v0__nor2_4_0 raw_mode \_008_ VDD VSS u_stuffer/_04_
+ gf180mcu_fd_sc_mcu9t5v0__nor2_4
* cell instance gf180mcu_fd_sc_mcu9t5v0__nor3_1_0 r0 *1 0,0
Xgf180mcu_fd_sc_mcu9t5v0__nor3_1_0 \_089_ \_095_ \_145_ VDD VSS \_049_
+ gf180mcu_fd_sc_mcu9t5v0__nor3_1
* cell instance gf180mcu_fd_sc_mcu9t5v0__nor3_1_1 r0 *1 0,0
Xgf180mcu_fd_sc_mcu9t5v0__nor3_1_1 u_sync_detector/_09_ u_sync_detector/_10_
+ u_sync_detector/_14_ VDD VSS u_sync_detector/_02_
+ gf180mcu_fd_sc_mcu9t5v0__nor3_1
* cell instance gf180mcu_fd_sc_mcu9t5v0__nor3_1_2 r0 *1 0,0
Xgf180mcu_fd_sc_mcu9t5v0__nor3_1_2 u_eop_detector/_09_ u_eop_detector/_24_
+ u_eop_detector/_25_ VDD VSS u_eop_detector/_05_
+ gf180mcu_fd_sc_mcu9t5v0__nor3_1
* cell instance gf180mcu_fd_sc_mcu9t5v0__nor3_1_3 r0 *1 0,0
Xgf180mcu_fd_sc_mcu9t5v0__nor3_1_3 \_010_ eop_pulse bus_reset VDD VSS \_138_
+ gf180mcu_fd_sc_mcu9t5v0__nor3_1
* cell instance gf180mcu_fd_sc_mcu9t5v0__nor3_1_4 r0 *1 0,0
Xgf180mcu_fd_sc_mcu9t5v0__nor3_1_4 u_eop_detector/se0_count[5]
+ u_eop_detector/_11_ u_eop_detector/se0_count[1] VDD VSS u_eop_detector/_12_
+ gf180mcu_fd_sc_mcu9t5v0__nor3_1
* cell instance gf180mcu_fd_sc_mcu9t5v0__nor3_1_5 r0 *1 0,0
Xgf180mcu_fd_sc_mcu9t5v0__nor3_1_5 u_eop_detector/_09_ u_eop_detector/_19_
+ u_eop_detector/_21_ VDD VSS u_eop_detector/_03_
+ gf180mcu_fd_sc_mcu9t5v0__nor3_1
* cell instance gf180mcu_fd_sc_mcu9t5v0__nor3_1_6 r0 *1 0,0
Xgf180mcu_fd_sc_mcu9t5v0__nor3_1_6 tx_state[7] nrzi_level \_069_ VDD VSS \_071_
+ gf180mcu_fd_sc_mcu9t5v0__nor3_1
* cell instance gf180mcu_fd_sc_mcu9t5v0__nor3_1_7 r0 *1 0,0
Xgf180mcu_fd_sc_mcu9t5v0__nor3_1_7 \_077_ OpMode[0] \_068_ VDD VSS \_009_
+ gf180mcu_fd_sc_mcu9t5v0__nor3_1
* cell instance gf180mcu_fd_sc_mcu9t5v0__nor3_1_8 r0 *1 0,0
Xgf180mcu_fd_sc_mcu9t5v0__nor3_1_8 u_stuffer/run[1] u_stuffer/_03_
+ u_stuffer/_05_ VDD VSS stuff_pending_after gf180mcu_fd_sc_mcu9t5v0__nor3_1
* cell instance gf180mcu_fd_sc_mcu9t5v0__nor3_1_9 r0 *1 0,0
Xgf180mcu_fd_sc_mcu9t5v0__nor3_1_9 \_066_ \_056_ \_057_ VDD VSS \_002_
+ gf180mcu_fd_sc_mcu9t5v0__nor3_1
* cell instance gf180mcu_fd_sc_mcu9t5v0__nor3_2_0 r0 *1 0,0
Xgf180mcu_fd_sc_mcu9t5v0__nor3_2_0 u_sync_detector/_09_ u_sync_detector/_11_
+ u_sync_detector/_12_ VDD VSS u_sync_detector/_01_
+ gf180mcu_fd_sc_mcu9t5v0__nor3_2
* cell instance gf180mcu_fd_sc_mcu9t5v0__nor3_2_1 r0 *1 0,0
Xgf180mcu_fd_sc_mcu9t5v0__nor3_2_1 u_sync_detector/_08_ u_sync_detector/_09_
+ u_sync_detector/_11_ VDD VSS u_sync_detector/_00_
+ gf180mcu_fd_sc_mcu9t5v0__nor3_2
* cell instance gf180mcu_fd_sc_mcu9t5v0__nor3_4_0 r0 *1 0,0
Xgf180mcu_fd_sc_mcu9t5v0__nor3_4_0 \_009_ nrzi_level entering_sync VDD VSS
+ u_encoder/_1_ gf180mcu_fd_sc_mcu9t5v0__nor3_4
* cell instance gf180mcu_fd_sc_mcu9t5v0__nor4_1_0 r0 *1 0,0
Xgf180mcu_fd_sc_mcu9t5v0__nor4_1_0 u_eop_detector/se0_count[3]
+ u_eop_detector/se0_count[4] u_eop_detector/se0_count[2] u_eop_detector/_09_
+ VDD VSS u_eop_detector/_26_ gf180mcu_fd_sc_mcu9t5v0__nor4_1
* cell instance gf180mcu_fd_sc_mcu9t5v0__nor4_1_1 r0 *1 0,0
Xgf180mcu_fd_sc_mcu9t5v0__nor4_1_1 tx_state[7] nrzi_level \_069_ \_070_ VDD VSS
+ txdm gf180mcu_fd_sc_mcu9t5v0__nor4_1
* cell instance gf180mcu_fd_sc_mcu9t5v0__nor4_1_2 r0 *1 0,0
Xgf180mcu_fd_sc_mcu9t5v0__nor4_1_2 tx_state[2] tx_state[6] tx_state[4]
+ tx_state[1] VDD VSS \_069_ gf180mcu_fd_sc_mcu9t5v0__nor4_1
* cell instance gf180mcu_fd_sc_mcu9t5v0__nor4_1_3 r0 *1 0,0
Xgf180mcu_fd_sc_mcu9t5v0__nor4_1_3 byte_idx[0] byte_idx[1] byte_idx[2] \_083_
+ VDD VSS \_008_ gf180mcu_fd_sc_mcu9t5v0__nor4_1
* cell instance gf180mcu_fd_sc_mcu9t5v0__nor4_4_0 r0 *1 0,0
Xgf180mcu_fd_sc_mcu9t5v0__nor4_4_0 u_sync_detector/match[3]
+ u_sync_detector/_05_ u_sync_detector/_06_ u_sync_detector/_07_ VDD VSS
+ sync_next gf180mcu_fd_sc_mcu9t5v0__nor4_4
* cell instance gf180mcu_fd_sc_mcu9t5v0__nor4_4_1 r0 *1 0,0
Xgf180mcu_fd_sc_mcu9t5v0__nor4_4_1 u_eop_detector/se0_count[5]
+ u_eop_detector/_11_ u_eop_detector/_14_ u_eop_detector/_10_ VDD VSS
+ u_eop_detector/_15_ gf180mcu_fd_sc_mcu9t5v0__nor4_4
* cell instance gf180mcu_fd_sc_mcu9t5v0__oai211_1_0 r0 *1 0,0
Xgf180mcu_fd_sc_mcu9t5v0__oai211_1_0 rx_bitcnt[2] \_095_ \_053_ rx_receiving
+ VDD VSS \_128_ gf180mcu_fd_sc_mcu9t5v0__oai211_1
* cell instance gf180mcu_fd_sc_mcu9t5v0__oai211_1_1 r0 *1 0,0
Xgf180mcu_fd_sc_mcu9t5v0__oai211_1_1 TxValid \_059_ \_060_ \_053_ VDD VSS
+ \_004_ gf180mcu_fd_sc_mcu9t5v0__oai211_1
* cell instance gf180mcu_fd_sc_mcu9t5v0__oai21_1_0 r0 *1 0,0
Xgf180mcu_fd_sc_mcu9t5v0__oai21_1_0 sync_next \_138_ \_053_ VDD VSS \_139_
+ gf180mcu_fd_sc_mcu9t5v0__oai21_1
* cell instance gf180mcu_fd_sc_mcu9t5v0__oai21_1_1 r0 *1 0,0
Xgf180mcu_fd_sc_mcu9t5v0__oai21_1_1 \_072_ \_055_ \_059_ VDD VSS TxReady
+ gf180mcu_fd_sc_mcu9t5v0__oai21_1
* cell instance gf180mcu_fd_sc_mcu9t5v0__oai21_1_2 r0 *1 0,0
Xgf180mcu_fd_sc_mcu9t5v0__oai21_1_2 TxValid \_074_ tx_state[2] VDD VSS \_075_
+ gf180mcu_fd_sc_mcu9t5v0__oai21_1
* cell instance gf180mcu_fd_sc_mcu9t5v0__oai21_1_3 r0 *1 0,0
Xgf180mcu_fd_sc_mcu9t5v0__oai21_1_3 byte_idx[0] byte_idx[1] tx_state[2] VDD VSS
+ \_140_ gf180mcu_fd_sc_mcu9t5v0__oai21_1
* cell instance gf180mcu_fd_sc_mcu9t5v0__oai221_2_0 r0 *1 0,0
Xgf180mcu_fd_sc_mcu9t5v0__oai221_2_0 TxValid \_055_ \_063_ \_062_ \_133_ VDD
+ VSS \_134_ gf180mcu_fd_sc_mcu9t5v0__oai221_2
* cell instance gf180mcu_fd_sc_mcu9t5v0__oai22_1_0 r0 *1 0,0
Xgf180mcu_fd_sc_mcu9t5v0__oai22_1_0 u_stuffer/_03_ tx_body_active
+ u_stuffer/_06_ u_stuffer/_08_ VDD VSS u_stuffer/_00_
+ gf180mcu_fd_sc_mcu9t5v0__oai22_1
* cell instance gf180mcu_fd_sc_mcu9t5v0__oai22_1_1 r0 *1 0,0
Xgf180mcu_fd_sc_mcu9t5v0__oai22_1_1 tx_state[2] \_061_ \_092_ \_124_ VDD VSS
+ \_125_ gf180mcu_fd_sc_mcu9t5v0__oai22_1
* cell instance gf180mcu_fd_sc_mcu9t5v0__oai31_1_0 r0 *1 0,0
Xgf180mcu_fd_sc_mcu9t5v0__oai31_1_0 stuff_pending_after \_056_ \_057_ \_058_
+ VDD VSS \_005_ gf180mcu_fd_sc_mcu9t5v0__oai31_1
* cell instance gf180mcu_fd_sc_mcu9t5v0__or2_1_0 r0 *1 0,0
Xgf180mcu_fd_sc_mcu9t5v0__or2_1_0 tx_state[5] tx_state[3] VDD VSS \_070_
+ gf180mcu_fd_sc_mcu9t5v0__or2_1
* cell instance gf180mcu_fd_sc_mcu9t5v0__or2_1_1 r0 *1 0,0
Xgf180mcu_fd_sc_mcu9t5v0__or2_1_1 TxValid \_055_ VDD VSS \_056_
+ gf180mcu_fd_sc_mcu9t5v0__or2_1
* cell instance gf180mcu_fd_sc_mcu9t5v0__or2_1_2 r0 *1 0,0
Xgf180mcu_fd_sc_mcu9t5v0__or2_1_2 sync_idx[1] \_120_ VDD VSS \_121_
+ gf180mcu_fd_sc_mcu9t5v0__or2_1
* cell instance gf180mcu_fd_sc_mcu9t5v0__or2_1_3 r0 *1 0,0
Xgf180mcu_fd_sc_mcu9t5v0__or2_1_3 \_062_ \_063_ VDD VSS \_064_
+ gf180mcu_fd_sc_mcu9t5v0__or2_1
* cell instance gf180mcu_fd_sc_mcu9t5v0__or3_2_0 r0 *1 0,0
Xgf180mcu_fd_sc_mcu9t5v0__or3_2_0 \_132_ \_080_ \_134_ VDD VSS \_135_
+ gf180mcu_fd_sc_mcu9t5v0__or3_2
* cell instance gf180mcu_fd_sc_mcu9t5v0__xnor2_1_0 r0 *1 0,0
Xgf180mcu_fd_sc_mcu9t5v0__xnor2_1_0 u_destuffer/ones_run[1] u_destuffer/_12_
+ VDD VSS u_destuffer/_13_ gf180mcu_fd_sc_mcu9t5v0__xnor2_1
* cell instance gf180mcu_fd_sc_mcu9t5v0__xnor2_1_1 r0 *1 0,0
Xgf180mcu_fd_sc_mcu9t5v0__xnor2_1_1 u_eop_detector/se0_count[2]
+ u_eop_detector/_15_ VDD VSS u_eop_detector/_16_
+ gf180mcu_fd_sc_mcu9t5v0__xnor2_1
* cell instance gf180mcu_fd_sc_mcu9t5v0__xnor2_1_2 r0 *1 0,0
Xgf180mcu_fd_sc_mcu9t5v0__xnor2_1_2 dec_bit_level u_decoder/prev_level VDD VSS
+ u_decoder/_03_ gf180mcu_fd_sc_mcu9t5v0__xnor2_1
* cell instance gf180mcu_fd_sc_mcu9t5v0__xnor2_4_0 r0 *1 0,0
Xgf180mcu_fd_sc_mcu9t5v0__xnor2_4_0 rx_bitcnt[0] \_086_ VDD VSS \_127_
+ gf180mcu_fd_sc_mcu9t5v0__xnor2_4
* cell instance gf180mcu_fd_sc_mcu9t5v0__xor2_1_0 r0 *1 0,0
Xgf180mcu_fd_sc_mcu9t5v0__xor2_1_0 line_state[0] line_state[1] VDD VSS
+ dec_bit_strobe gf180mcu_fd_sc_mcu9t5v0__xor2_1
* cell instance gf180mcu_fd_sc_mcu9t5v0__xor2_1_1 r0 *1 0,0
Xgf180mcu_fd_sc_mcu9t5v0__xor2_1_1 u_stuffer/run[1] u_stuffer/_10_ VDD VSS
+ u_stuffer/_11_ gf180mcu_fd_sc_mcu9t5v0__xor2_1
* cell instance gf180mcu_fd_sc_mcu9t5v0__xor2_2_0 r0 *1 0,0
Xgf180mcu_fd_sc_mcu9t5v0__xor2_2_0 \_013_ u_encoder/_1_ VDD VSS u_encoder/_2_
+ gf180mcu_fd_sc_mcu9t5v0__xor2_2
* cell instance gf180mcu_fd_sc_mcu9t5v0__xor2_2_1 r0 *1 0,0
Xgf180mcu_fd_sc_mcu9t5v0__xor2_2_1 u_stuffer/run[2] u_stuffer/_12_ VDD VSS
+ u_stuffer/_13_ gf180mcu_fd_sc_mcu9t5v0__xor2_2
.ENDS usb_utmi_phy

* cell gf180mcu_fd_sc_mcu9t5v0__xor2_2
* pin A1
* pin A2
* pin VDD
* pin VSS
* pin Z
.SUBCKT gf180mcu_fd_sc_mcu9t5v0__xor2_2 A1 A2 VDD VSS Z
.ENDS gf180mcu_fd_sc_mcu9t5v0__xor2_2

* cell gf180mcu_fd_sc_mcu9t5v0__xor2_1
* pin A1
* pin A2
* pin VDD
* pin VSS
* pin Z
.SUBCKT gf180mcu_fd_sc_mcu9t5v0__xor2_1 A1 A2 VDD VSS Z
.ENDS gf180mcu_fd_sc_mcu9t5v0__xor2_1

* cell gf180mcu_fd_sc_mcu9t5v0__xnor2_4
* pin A1
* pin A2
* pin VDD
* pin VSS
* pin ZN
.SUBCKT gf180mcu_fd_sc_mcu9t5v0__xnor2_4 A1 A2 VDD VSS ZN
.ENDS gf180mcu_fd_sc_mcu9t5v0__xnor2_4

* cell gf180mcu_fd_sc_mcu9t5v0__xnor2_1
* pin A1
* pin A2
* pin VDD
* pin VSS
* pin ZN
.SUBCKT gf180mcu_fd_sc_mcu9t5v0__xnor2_1 A1 A2 VDD VSS ZN
.ENDS gf180mcu_fd_sc_mcu9t5v0__xnor2_1

* cell gf180mcu_fd_sc_mcu9t5v0__or3_2
* pin A1
* pin A2
* pin A3
* pin VDD
* pin VSS
* pin Z
.SUBCKT gf180mcu_fd_sc_mcu9t5v0__or3_2 A1 A2 A3 VDD VSS Z
.ENDS gf180mcu_fd_sc_mcu9t5v0__or3_2

* cell gf180mcu_fd_sc_mcu9t5v0__or2_1
* pin A1
* pin A2
* pin VDD
* pin VSS
* pin Z
.SUBCKT gf180mcu_fd_sc_mcu9t5v0__or2_1 A1 A2 VDD VSS Z
.ENDS gf180mcu_fd_sc_mcu9t5v0__or2_1

* cell gf180mcu_fd_sc_mcu9t5v0__oai31_1
* pin A1
* pin A2
* pin A3
* pin B
* pin VDD
* pin VSS
* pin ZN
.SUBCKT gf180mcu_fd_sc_mcu9t5v0__oai31_1 A1 A2 A3 B VDD VSS ZN
.ENDS gf180mcu_fd_sc_mcu9t5v0__oai31_1

* cell gf180mcu_fd_sc_mcu9t5v0__oai22_1
* pin A1
* pin A2
* pin B1
* pin B2
* pin VDD
* pin VSS
* pin ZN
.SUBCKT gf180mcu_fd_sc_mcu9t5v0__oai22_1 A1 A2 B1 B2 VDD VSS ZN
.ENDS gf180mcu_fd_sc_mcu9t5v0__oai22_1

* cell gf180mcu_fd_sc_mcu9t5v0__oai221_2
* pin A1
* pin A2
* pin B1
* pin B2
* pin C
* pin VDD
* pin VSS
* pin ZN
.SUBCKT gf180mcu_fd_sc_mcu9t5v0__oai221_2 A1 A2 B1 B2 C VDD VSS ZN
.ENDS gf180mcu_fd_sc_mcu9t5v0__oai221_2

* cell gf180mcu_fd_sc_mcu9t5v0__oai21_1
* pin A1
* pin A2
* pin B
* pin VDD
* pin VSS
* pin ZN
.SUBCKT gf180mcu_fd_sc_mcu9t5v0__oai21_1 A1 A2 B VDD VSS ZN
.ENDS gf180mcu_fd_sc_mcu9t5v0__oai21_1

* cell gf180mcu_fd_sc_mcu9t5v0__oai211_1
* pin A1
* pin A2
* pin B
* pin C
* pin VDD
* pin VSS
* pin ZN
.SUBCKT gf180mcu_fd_sc_mcu9t5v0__oai211_1 A1 A2 B C VDD VSS ZN
.ENDS gf180mcu_fd_sc_mcu9t5v0__oai211_1

* cell gf180mcu_fd_sc_mcu9t5v0__nor4_4
* pin A1
* pin A2
* pin A3
* pin A4
* pin VDD
* pin VSS
* pin ZN
.SUBCKT gf180mcu_fd_sc_mcu9t5v0__nor4_4 A1 A2 A3 A4 VDD VSS ZN
.ENDS gf180mcu_fd_sc_mcu9t5v0__nor4_4

* cell gf180mcu_fd_sc_mcu9t5v0__nor4_1
* pin A1
* pin A2
* pin A3
* pin A4
* pin VDD
* pin VSS
* pin ZN
.SUBCKT gf180mcu_fd_sc_mcu9t5v0__nor4_1 A1 A2 A3 A4 VDD VSS ZN
.ENDS gf180mcu_fd_sc_mcu9t5v0__nor4_1

* cell gf180mcu_fd_sc_mcu9t5v0__nor3_4
* pin A1
* pin A2
* pin A3
* pin VDD
* pin VSS
* pin ZN
.SUBCKT gf180mcu_fd_sc_mcu9t5v0__nor3_4 A1 A2 A3 VDD VSS ZN
.ENDS gf180mcu_fd_sc_mcu9t5v0__nor3_4

* cell gf180mcu_fd_sc_mcu9t5v0__nor3_2
* pin A1
* pin A2
* pin A3
* pin VDD
* pin VSS
* pin ZN
.SUBCKT gf180mcu_fd_sc_mcu9t5v0__nor3_2 A1 A2 A3 VDD VSS ZN
.ENDS gf180mcu_fd_sc_mcu9t5v0__nor3_2

* cell gf180mcu_fd_sc_mcu9t5v0__nor3_1
* pin A1
* pin A2
* pin A3
* pin VDD
* pin VSS
* pin ZN
.SUBCKT gf180mcu_fd_sc_mcu9t5v0__nor3_1 A1 A2 A3 VDD VSS ZN
.ENDS gf180mcu_fd_sc_mcu9t5v0__nor3_1

* cell gf180mcu_fd_sc_mcu9t5v0__nor2_4
* pin A1
* pin A2
* pin VDD
* pin VSS
* pin ZN
.SUBCKT gf180mcu_fd_sc_mcu9t5v0__nor2_4 A1 A2 VDD VSS ZN
.ENDS gf180mcu_fd_sc_mcu9t5v0__nor2_4

* cell gf180mcu_fd_sc_mcu9t5v0__nor2_2
* pin A1
* pin A2
* pin VDD
* pin VSS
* pin ZN
.SUBCKT gf180mcu_fd_sc_mcu9t5v0__nor2_2 A1 A2 VDD VSS ZN
.ENDS gf180mcu_fd_sc_mcu9t5v0__nor2_2

* cell gf180mcu_fd_sc_mcu9t5v0__nor2_1
* pin A1
* pin A2
* pin VDD
* pin VSS
* pin ZN
.SUBCKT gf180mcu_fd_sc_mcu9t5v0__nor2_1 A1 A2 VDD VSS ZN
.ENDS gf180mcu_fd_sc_mcu9t5v0__nor2_1

* cell gf180mcu_fd_sc_mcu9t5v0__nand4_4
* pin A1
* pin A2
* pin A3
* pin A4
* pin VDD
* pin VSS
* pin ZN
.SUBCKT gf180mcu_fd_sc_mcu9t5v0__nand4_4 A1 A2 A3 A4 VDD VSS ZN
.ENDS gf180mcu_fd_sc_mcu9t5v0__nand4_4

* cell gf180mcu_fd_sc_mcu9t5v0__nand4_1
* pin A1
* pin A2
* pin A3
* pin A4
* pin VDD
* pin VSS
* pin ZN
.SUBCKT gf180mcu_fd_sc_mcu9t5v0__nand4_1 A1 A2 A3 A4 VDD VSS ZN
.ENDS gf180mcu_fd_sc_mcu9t5v0__nand4_1

* cell gf180mcu_fd_sc_mcu9t5v0__nand3_4
* pin A1
* pin A2
* pin A3
* pin VDD
* pin VSS
* pin ZN
.SUBCKT gf180mcu_fd_sc_mcu9t5v0__nand3_4 A1 A2 A3 VDD VSS ZN
.ENDS gf180mcu_fd_sc_mcu9t5v0__nand3_4

* cell gf180mcu_fd_sc_mcu9t5v0__nand3_2
* pin A1
* pin A2
* pin A3
* pin VDD
* pin VSS
* pin ZN
.SUBCKT gf180mcu_fd_sc_mcu9t5v0__nand3_2 A1 A2 A3 VDD VSS ZN
.ENDS gf180mcu_fd_sc_mcu9t5v0__nand3_2

* cell gf180mcu_fd_sc_mcu9t5v0__nand3_1
* pin A1
* pin A2
* pin A3
* pin VDD
* pin VSS
* pin ZN
.SUBCKT gf180mcu_fd_sc_mcu9t5v0__nand3_1 A1 A2 A3 VDD VSS ZN
.ENDS gf180mcu_fd_sc_mcu9t5v0__nand3_1

* cell gf180mcu_fd_sc_mcu9t5v0__nand2_4
* pin A1
* pin A2
* pin VDD
* pin VSS
* pin ZN
.SUBCKT gf180mcu_fd_sc_mcu9t5v0__nand2_4 A1 A2 VDD VSS ZN
.ENDS gf180mcu_fd_sc_mcu9t5v0__nand2_4

* cell gf180mcu_fd_sc_mcu9t5v0__nand2_2
* pin A1
* pin A2
* pin VDD
* pin VSS
* pin ZN
.SUBCKT gf180mcu_fd_sc_mcu9t5v0__nand2_2 A1 A2 VDD VSS ZN
.ENDS gf180mcu_fd_sc_mcu9t5v0__nand2_2

* cell gf180mcu_fd_sc_mcu9t5v0__nand2_1
* pin A1
* pin A2
* pin VDD
* pin VSS
* pin ZN
.SUBCKT gf180mcu_fd_sc_mcu9t5v0__nand2_1 A1 A2 VDD VSS ZN
.ENDS gf180mcu_fd_sc_mcu9t5v0__nand2_1

* cell gf180mcu_fd_sc_mcu9t5v0__mux4_1
* pin I0
* pin I1
* pin I2
* pin I3
* pin S0
* pin S1
* pin VDD
* pin VSS
* pin Z
.SUBCKT gf180mcu_fd_sc_mcu9t5v0__mux4_1 I0 I1 I2 I3 S0 S1 VDD VSS Z
.ENDS gf180mcu_fd_sc_mcu9t5v0__mux4_1

* cell gf180mcu_fd_sc_mcu9t5v0__mux2_2
* pin I0
* pin I1
* pin S
* pin VDD
* pin VSS
* pin Z
.SUBCKT gf180mcu_fd_sc_mcu9t5v0__mux2_2 I0 I1 S VDD VSS Z
.ENDS gf180mcu_fd_sc_mcu9t5v0__mux2_2

* cell gf180mcu_fd_sc_mcu9t5v0__mux2_1
* pin I0
* pin I1
* pin S
* pin VDD
* pin VSS
* pin Z
.SUBCKT gf180mcu_fd_sc_mcu9t5v0__mux2_1 I0 I1 S VDD VSS Z
.ENDS gf180mcu_fd_sc_mcu9t5v0__mux2_1

* cell gf180mcu_fd_sc_mcu9t5v0__inv_8
* pin I
* pin VDD
* pin VSS
* pin ZN
.SUBCKT gf180mcu_fd_sc_mcu9t5v0__inv_8 I VDD VSS ZN
.ENDS gf180mcu_fd_sc_mcu9t5v0__inv_8

* cell gf180mcu_fd_sc_mcu9t5v0__inv_4
* pin I
* pin VDD
* pin VSS
* pin ZN
.SUBCKT gf180mcu_fd_sc_mcu9t5v0__inv_4 I VDD VSS ZN
.ENDS gf180mcu_fd_sc_mcu9t5v0__inv_4

* cell gf180mcu_fd_sc_mcu9t5v0__inv_3
* pin I
* pin VDD
* pin VSS
* pin ZN
.SUBCKT gf180mcu_fd_sc_mcu9t5v0__inv_3 I VDD VSS ZN
.ENDS gf180mcu_fd_sc_mcu9t5v0__inv_3

* cell gf180mcu_fd_sc_mcu9t5v0__inv_2
* pin I
* pin VDD
* pin VSS
* pin ZN
.SUBCKT gf180mcu_fd_sc_mcu9t5v0__inv_2 I VDD VSS ZN
.ENDS gf180mcu_fd_sc_mcu9t5v0__inv_2

* cell gf180mcu_fd_sc_mcu9t5v0__inv_1
* pin I
* pin VDD
* pin VSS
* pin ZN
.SUBCKT gf180mcu_fd_sc_mcu9t5v0__inv_1 I VDD VSS ZN
.ENDS gf180mcu_fd_sc_mcu9t5v0__inv_1

* cell gf180mcu_fd_sc_mcu9t5v0__filltie
* pin VDD
* pin VSS
.SUBCKT gf180mcu_fd_sc_mcu9t5v0__filltie VDD VSS
.ENDS gf180mcu_fd_sc_mcu9t5v0__filltie

* cell gf180mcu_fd_sc_mcu9t5v0__fill_8
* pin VDD
* pin VSS
.SUBCKT gf180mcu_fd_sc_mcu9t5v0__fill_8 VDD VSS
.ENDS gf180mcu_fd_sc_mcu9t5v0__fill_8

* cell gf180mcu_fd_sc_mcu9t5v0__fill_64
* pin VDD
* pin VSS
.SUBCKT gf180mcu_fd_sc_mcu9t5v0__fill_64 VDD VSS
.ENDS gf180mcu_fd_sc_mcu9t5v0__fill_64

* cell gf180mcu_fd_sc_mcu9t5v0__fill_4
* pin VDD
* pin VSS
.SUBCKT gf180mcu_fd_sc_mcu9t5v0__fill_4 VDD VSS
.ENDS gf180mcu_fd_sc_mcu9t5v0__fill_4

* cell gf180mcu_fd_sc_mcu9t5v0__fill_32
* pin VDD
* pin VSS
.SUBCKT gf180mcu_fd_sc_mcu9t5v0__fill_32 VDD VSS
.ENDS gf180mcu_fd_sc_mcu9t5v0__fill_32

* cell gf180mcu_fd_sc_mcu9t5v0__fill_2
* pin VDD
* pin VSS
.SUBCKT gf180mcu_fd_sc_mcu9t5v0__fill_2 VDD VSS
.ENDS gf180mcu_fd_sc_mcu9t5v0__fill_2

* cell gf180mcu_fd_sc_mcu9t5v0__fill_16
* pin VDD
* pin VSS
.SUBCKT gf180mcu_fd_sc_mcu9t5v0__fill_16 VDD VSS
.ENDS gf180mcu_fd_sc_mcu9t5v0__fill_16

* cell gf180mcu_fd_sc_mcu9t5v0__fill_1
* pin VDD
* pin VSS
.SUBCKT gf180mcu_fd_sc_mcu9t5v0__fill_1 VDD VSS
.ENDS gf180mcu_fd_sc_mcu9t5v0__fill_1

* cell gf180mcu_fd_sc_mcu9t5v0__endcap
* pin VDD
* pin VSS
.SUBCKT gf180mcu_fd_sc_mcu9t5v0__endcap VDD VSS
.ENDS gf180mcu_fd_sc_mcu9t5v0__endcap

* cell gf180mcu_fd_sc_mcu9t5v0__dffsnq_1
* pin CLK
* pin D
* pin Q
* pin SETN
* pin VDD
* pin VSS
.SUBCKT gf180mcu_fd_sc_mcu9t5v0__dffsnq_1 CLK D Q SETN VDD VSS
.ENDS gf180mcu_fd_sc_mcu9t5v0__dffsnq_1

* cell gf180mcu_fd_sc_mcu9t5v0__dffrnq_1
* pin CLK
* pin D
* pin Q
* pin RN
* pin VDD
* pin VSS
.SUBCKT gf180mcu_fd_sc_mcu9t5v0__dffrnq_1 CLK D Q RN VDD VSS
.ENDS gf180mcu_fd_sc_mcu9t5v0__dffrnq_1

* cell gf180mcu_fd_sc_mcu9t5v0__dffq_1
* pin CLK
* pin D
* pin Q
* pin VDD
* pin VSS
.SUBCKT gf180mcu_fd_sc_mcu9t5v0__dffq_1 CLK D Q VDD VSS
.ENDS gf180mcu_fd_sc_mcu9t5v0__dffq_1

* cell gf180mcu_fd_sc_mcu9t5v0__clkinv_8
* pin I
* pin VDD
* pin VSS
* pin ZN
.SUBCKT gf180mcu_fd_sc_mcu9t5v0__clkinv_8 I VDD VSS ZN
.ENDS gf180mcu_fd_sc_mcu9t5v0__clkinv_8

* cell gf180mcu_fd_sc_mcu9t5v0__clkinv_1
* pin I
* pin VDD
* pin VSS
* pin ZN
.SUBCKT gf180mcu_fd_sc_mcu9t5v0__clkinv_1 I VDD VSS ZN
.ENDS gf180mcu_fd_sc_mcu9t5v0__clkinv_1

* cell gf180mcu_fd_sc_mcu9t5v0__buf_4
* pin I
* pin VDD
* pin VSS
* pin Z
.SUBCKT gf180mcu_fd_sc_mcu9t5v0__buf_4 I VDD VSS Z
.ENDS gf180mcu_fd_sc_mcu9t5v0__buf_4

* cell gf180mcu_fd_sc_mcu9t5v0__aoi22_4
* pin A1
* pin A2
* pin B1
* pin B2
* pin VDD
* pin VSS
* pin ZN
.SUBCKT gf180mcu_fd_sc_mcu9t5v0__aoi22_4 A1 A2 B1 B2 VDD VSS ZN
.ENDS gf180mcu_fd_sc_mcu9t5v0__aoi22_4

* cell gf180mcu_fd_sc_mcu9t5v0__aoi221_1
* pin A1
* pin A2
* pin B1
* pin B2
* pin C
* pin VDD
* pin VSS
* pin ZN
.SUBCKT gf180mcu_fd_sc_mcu9t5v0__aoi221_1 A1 A2 B1 B2 C VDD VSS ZN
.ENDS gf180mcu_fd_sc_mcu9t5v0__aoi221_1

* cell gf180mcu_fd_sc_mcu9t5v0__aoi21_4
* pin A1
* pin A2
* pin B
* pin VDD
* pin VSS
* pin ZN
.SUBCKT gf180mcu_fd_sc_mcu9t5v0__aoi21_4 A1 A2 B VDD VSS ZN
.ENDS gf180mcu_fd_sc_mcu9t5v0__aoi21_4

* cell gf180mcu_fd_sc_mcu9t5v0__aoi21_2
* pin A1
* pin A2
* pin B
* pin VDD
* pin VSS
* pin ZN
.SUBCKT gf180mcu_fd_sc_mcu9t5v0__aoi21_2 A1 A2 B VDD VSS ZN
.ENDS gf180mcu_fd_sc_mcu9t5v0__aoi21_2

* cell gf180mcu_fd_sc_mcu9t5v0__aoi21_1
* pin A1
* pin A2
* pin B
* pin VDD
* pin VSS
* pin ZN
.SUBCKT gf180mcu_fd_sc_mcu9t5v0__aoi21_1 A1 A2 B VDD VSS ZN
.ENDS gf180mcu_fd_sc_mcu9t5v0__aoi21_1

* cell gf180mcu_fd_sc_mcu9t5v0__aoi211_2
* pin A1
* pin A2
* pin B
* pin C
* pin VDD
* pin VSS
* pin ZN
.SUBCKT gf180mcu_fd_sc_mcu9t5v0__aoi211_2 A1 A2 B C VDD VSS ZN
.ENDS gf180mcu_fd_sc_mcu9t5v0__aoi211_2

* cell gf180mcu_fd_sc_mcu9t5v0__aoi211_1
* pin A1
* pin A2
* pin B
* pin C
* pin VDD
* pin VSS
* pin ZN
.SUBCKT gf180mcu_fd_sc_mcu9t5v0__aoi211_1 A1 A2 B C VDD VSS ZN
.ENDS gf180mcu_fd_sc_mcu9t5v0__aoi211_1

* cell gf180mcu_fd_sc_mcu9t5v0__and4_4
* pin A1
* pin A2
* pin A3
* pin A4
* pin VDD
* pin VSS
* pin Z
.SUBCKT gf180mcu_fd_sc_mcu9t5v0__and4_4 A1 A2 A3 A4 VDD VSS Z
.ENDS gf180mcu_fd_sc_mcu9t5v0__and4_4

* cell gf180mcu_fd_sc_mcu9t5v0__and4_1
* pin A1
* pin A2
* pin A3
* pin A4
* pin VDD
* pin VSS
* pin Z
.SUBCKT gf180mcu_fd_sc_mcu9t5v0__and4_1 A1 A2 A3 A4 VDD VSS Z
.ENDS gf180mcu_fd_sc_mcu9t5v0__and4_1

* cell gf180mcu_fd_sc_mcu9t5v0__and3_4
* pin A1
* pin A2
* pin A3
* pin VDD
* pin VSS
* pin Z
.SUBCKT gf180mcu_fd_sc_mcu9t5v0__and3_4 A1 A2 A3 VDD VSS Z
.ENDS gf180mcu_fd_sc_mcu9t5v0__and3_4

* cell gf180mcu_fd_sc_mcu9t5v0__and3_2
* pin A1
* pin A2
* pin A3
* pin VDD
* pin VSS
* pin Z
.SUBCKT gf180mcu_fd_sc_mcu9t5v0__and3_2 A1 A2 A3 VDD VSS Z
.ENDS gf180mcu_fd_sc_mcu9t5v0__and3_2

* cell gf180mcu_fd_sc_mcu9t5v0__and3_1
* pin A1
* pin A2
* pin A3
* pin VDD
* pin VSS
* pin Z
.SUBCKT gf180mcu_fd_sc_mcu9t5v0__and3_1 A1 A2 A3 VDD VSS Z
.ENDS gf180mcu_fd_sc_mcu9t5v0__and3_1

* cell gf180mcu_fd_sc_mcu9t5v0__and2_4
* pin A1
* pin A2
* pin VDD
* pin VSS
* pin Z
.SUBCKT gf180mcu_fd_sc_mcu9t5v0__and2_4 A1 A2 VDD VSS Z
.ENDS gf180mcu_fd_sc_mcu9t5v0__and2_4

* cell gf180mcu_fd_sc_mcu9t5v0__and2_2
* pin A1
* pin A2
* pin VDD
* pin VSS
* pin Z
.SUBCKT gf180mcu_fd_sc_mcu9t5v0__and2_2 A1 A2 VDD VSS Z
.ENDS gf180mcu_fd_sc_mcu9t5v0__and2_2

* cell gf180mcu_fd_sc_mcu9t5v0__and2_1
* pin A1
* pin A2
* pin VDD
* pin VSS
* pin Z
.SUBCKT gf180mcu_fd_sc_mcu9t5v0__and2_1 A1 A2 VDD VSS Z
.ENDS gf180mcu_fd_sc_mcu9t5v0__and2_1
