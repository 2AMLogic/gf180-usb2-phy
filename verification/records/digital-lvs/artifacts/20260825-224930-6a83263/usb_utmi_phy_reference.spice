* reference netlist for `klt lvs`, generated by scripts/digital_lvs.py
* source: the as-built gate-level Verilog from `klt place-and-route`

.SUBCKT gf180mcu_fd_sc_mcu9t5v0__and2_1 A1 A2 VDD VSS Z
.ENDS
.SUBCKT gf180mcu_fd_sc_mcu9t5v0__and2_2 A1 A2 VDD VSS Z
.ENDS
.SUBCKT gf180mcu_fd_sc_mcu9t5v0__and2_4 A1 A2 VDD VSS Z
.ENDS
.SUBCKT gf180mcu_fd_sc_mcu9t5v0__and3_1 A1 A2 A3 VDD VSS Z
.ENDS
.SUBCKT gf180mcu_fd_sc_mcu9t5v0__and3_2 A1 A2 A3 VDD VSS Z
.ENDS
.SUBCKT gf180mcu_fd_sc_mcu9t5v0__and3_4 A1 A2 A3 VDD VSS Z
.ENDS
.SUBCKT gf180mcu_fd_sc_mcu9t5v0__and4_4 A1 A2 A3 A4 VDD VSS Z
.ENDS
.SUBCKT gf180mcu_fd_sc_mcu9t5v0__aoi211_1 A1 A2 B C VDD VSS ZN
.ENDS
.SUBCKT gf180mcu_fd_sc_mcu9t5v0__aoi211_2 A1 A2 B C VDD VSS ZN
.ENDS
.SUBCKT gf180mcu_fd_sc_mcu9t5v0__aoi21_1 A1 A2 B VDD VSS ZN
.ENDS
.SUBCKT gf180mcu_fd_sc_mcu9t5v0__aoi21_2 A1 A2 B VDD VSS ZN
.ENDS
.SUBCKT gf180mcu_fd_sc_mcu9t5v0__aoi21_4 A1 A2 B VDD VSS ZN
.ENDS
.SUBCKT gf180mcu_fd_sc_mcu9t5v0__aoi221_1 A1 A2 B1 B2 C VDD VSS ZN
.ENDS
.SUBCKT gf180mcu_fd_sc_mcu9t5v0__buf_4 I VDD VSS Z
.ENDS
.SUBCKT gf180mcu_fd_sc_mcu9t5v0__clkinv_1 I VDD VSS ZN
.ENDS
.SUBCKT gf180mcu_fd_sc_mcu9t5v0__clkinv_2 I VDD VSS ZN
.ENDS
.SUBCKT gf180mcu_fd_sc_mcu9t5v0__clkinv_3 I VDD VSS ZN
.ENDS
.SUBCKT gf180mcu_fd_sc_mcu9t5v0__clkinv_8 I VDD VSS ZN
.ENDS
.SUBCKT gf180mcu_fd_sc_mcu9t5v0__dffq_1 CLK D Q VDD VSS
.ENDS
.SUBCKT gf180mcu_fd_sc_mcu9t5v0__inv_1 I VDD VSS ZN
.ENDS
.SUBCKT gf180mcu_fd_sc_mcu9t5v0__inv_2 I VDD VSS ZN
.ENDS
.SUBCKT gf180mcu_fd_sc_mcu9t5v0__inv_3 I VDD VSS ZN
.ENDS
.SUBCKT gf180mcu_fd_sc_mcu9t5v0__inv_4 I VDD VSS ZN
.ENDS
.SUBCKT gf180mcu_fd_sc_mcu9t5v0__mux2_1 I0 I1 S VDD VSS Z
.ENDS
.SUBCKT gf180mcu_fd_sc_mcu9t5v0__mux2_2 I0 I1 S VDD VSS Z
.ENDS
.SUBCKT gf180mcu_fd_sc_mcu9t5v0__mux4_1 I0 I1 I2 I3 S0 S1 VDD VSS Z
.ENDS
.SUBCKT gf180mcu_fd_sc_mcu9t5v0__nand2_1 A1 A2 VDD VSS ZN
.ENDS
.SUBCKT gf180mcu_fd_sc_mcu9t5v0__nand2_2 A1 A2 VDD VSS ZN
.ENDS
.SUBCKT gf180mcu_fd_sc_mcu9t5v0__nand2_4 A1 A2 VDD VSS ZN
.ENDS
.SUBCKT gf180mcu_fd_sc_mcu9t5v0__nand3_1 A1 A2 A3 VDD VSS ZN
.ENDS
.SUBCKT gf180mcu_fd_sc_mcu9t5v0__nand3_2 A1 A2 A3 VDD VSS ZN
.ENDS
.SUBCKT gf180mcu_fd_sc_mcu9t5v0__nand3_4 A1 A2 A3 VDD VSS ZN
.ENDS
.SUBCKT gf180mcu_fd_sc_mcu9t5v0__nand4_1 A1 A2 A3 A4 VDD VSS ZN
.ENDS
.SUBCKT gf180mcu_fd_sc_mcu9t5v0__nand4_4 A1 A2 A3 A4 VDD VSS ZN
.ENDS
.SUBCKT gf180mcu_fd_sc_mcu9t5v0__nor2_1 A1 A2 VDD VSS ZN
.ENDS
.SUBCKT gf180mcu_fd_sc_mcu9t5v0__nor2_2 A1 A2 VDD VSS ZN
.ENDS
.SUBCKT gf180mcu_fd_sc_mcu9t5v0__nor2_4 A1 A2 VDD VSS ZN
.ENDS
.SUBCKT gf180mcu_fd_sc_mcu9t5v0__nor3_1 A1 A2 A3 VDD VSS ZN
.ENDS
.SUBCKT gf180mcu_fd_sc_mcu9t5v0__nor3_2 A1 A2 A3 VDD VSS ZN
.ENDS
.SUBCKT gf180mcu_fd_sc_mcu9t5v0__nor4_1 A1 A2 A3 A4 VDD VSS ZN
.ENDS
.SUBCKT gf180mcu_fd_sc_mcu9t5v0__nor4_2 A1 A2 A3 A4 VDD VSS ZN
.ENDS
.SUBCKT gf180mcu_fd_sc_mcu9t5v0__nor4_4 A1 A2 A3 A4 VDD VSS ZN
.ENDS
.SUBCKT gf180mcu_fd_sc_mcu9t5v0__oai211_1 A1 A2 B C VDD VSS ZN
.ENDS
.SUBCKT gf180mcu_fd_sc_mcu9t5v0__oai211_2 A1 A2 B C VDD VSS ZN
.ENDS
.SUBCKT gf180mcu_fd_sc_mcu9t5v0__oai21_1 A1 A2 B VDD VSS ZN
.ENDS
.SUBCKT gf180mcu_fd_sc_mcu9t5v0__oai21_4 A1 A2 B VDD VSS ZN
.ENDS
.SUBCKT gf180mcu_fd_sc_mcu9t5v0__oai22_1 A1 A2 B1 B2 VDD VSS ZN
.ENDS
.SUBCKT gf180mcu_fd_sc_mcu9t5v0__oai32_4 A1 A2 A3 B1 B2 VDD VSS ZN
.ENDS
.SUBCKT gf180mcu_fd_sc_mcu9t5v0__or2_1 A1 A2 VDD VSS Z
.ENDS
.SUBCKT gf180mcu_fd_sc_mcu9t5v0__or2_2 A1 A2 VDD VSS Z
.ENDS
.SUBCKT gf180mcu_fd_sc_mcu9t5v0__or3_4 A1 A2 A3 VDD VSS Z
.ENDS
.SUBCKT gf180mcu_fd_sc_mcu9t5v0__tiel VDD VSS ZN
.ENDS
.SUBCKT gf180mcu_fd_sc_mcu9t5v0__xnor2_1 A1 A2 VDD VSS ZN
.ENDS
.SUBCKT gf180mcu_fd_sc_mcu9t5v0__xor2_1 A1 A2 VDD VSS Z
.ENDS
.SUBCKT gf180mcu_fd_sc_mcu9t5v0__xor2_2 A1 A2 VDD VSS Z
.ENDS

.SUBCKT usb_utmi_phy DataIn[0] DataIn[1] DataIn[2] DataIn[3] DataIn[4] DataIn[5] DataIn[6] DataIn[7] DataOut[0] DataOut[1] DataOut[2] DataOut[3] DataOut[4] DataOut[5] DataOut[6] DataOut[7] Reset RxError RxValid TxReady TxValid VDD VSS clk line_state[0] line_state[1] rst_n rx_receiving rxdm rxdp txdm txdp OpMode[0] OpMode[1] SuspendM TermSelect XcvrSelect
X\_146_ rx_receiving VDD VSS \_009_ gf180mcu_fd_sc_mcu9t5v0__inv_1
X\_147_ rst_n VDD VSS \_053_ gf180mcu_fd_sc_mcu9t5v0__inv_1
X\_148_ \_053_ Reset VDD VSS \_054_ gf180mcu_fd_sc_mcu9t5v0__or2_2
X\_149_ \_054_ VDD VSS int_rst_n gf180mcu_fd_sc_mcu9t5v0__clkinv_1
X\_150_ tx_bitidx[0] tx_bitidx[2] tx_bitidx[1] stuff_in_ready VDD VSS \_055_ gf180mcu_fd_sc_mcu9t5v0__and4_4
X\_151_ tx_state[3] VDD VSS \_056_ gf180mcu_fd_sc_mcu9t5v0__inv_3
X\_152_ next_valid \_056_ VDD VSS \_057_ gf180mcu_fd_sc_mcu9t5v0__nor2_4
X\_153_ int_rst_n \_055_ \_057_ VDD VSS \_005_ gf180mcu_fd_sc_mcu9t5v0__and3_1
X\_154_ tx_state[7] VDD VSS \_058_ gf180mcu_fd_sc_mcu9t5v0__clkinv_1
X\_156_ \_058_ \_054_ VDD VSS \_001_ gf180mcu_fd_sc_mcu9t5v0__nor2_1
X\_157_ tx_state[5] VDD VSS \_060_ gf180mcu_fd_sc_mcu9t5v0__clkinv_1
X\_158_ tx_bitidx[0] tx_bitidx[2] tx_bitidx[1] stuff_in_ready VDD VSS \_061_ gf180mcu_fd_sc_mcu9t5v0__nand4_1
X\_160_ next_valid \_061_ tx_state[3] VDD VSS \_063_ gf180mcu_fd_sc_mcu9t5v0__oai21_1
X\_161_ \_060_ \_063_ \_054_ VDD VSS \_008_ gf180mcu_fd_sc_mcu9t5v0__aoi21_1
X\_162_ tx_state[0] TxValid int_rst_n VDD VSS \_003_ gf180mcu_fd_sc_mcu9t5v0__and3_1
X\_163_ tx_state[4] int_rst_n VDD VSS \_006_ gf180mcu_fd_sc_mcu9t5v0__and2_1
X\_164_ tx_state[0] VDD VSS \_064_ gf180mcu_fd_sc_mcu9t5v0__clkinv_1
X\_165_ tx_state[1] \_054_ VDD VSS \_065_ gf180mcu_fd_sc_mcu9t5v0__nor2_1
X\_166_ \_064_ TxValid \_065_ VDD VSS \_007_ gf180mcu_fd_sc_mcu9t5v0__oai21_1
X\_167_ tx_state[2] int_rst_n VDD VSS \_004_ gf180mcu_fd_sc_mcu9t5v0__and2_1
X\_168_ tx_state[6] int_rst_n VDD VSS \_002_ gf180mcu_fd_sc_mcu9t5v0__and2_1
X\_169_ rx_receiving dec_data_valid VDD VSS destuff_in_valid gf180mcu_fd_sc_mcu9t5v0__and2_1
X\_170_ line_state[0] VDD VSS \_066_ gf180mcu_fd_sc_mcu9t5v0__clkinv_1
X\_171_ \_066_ line_state[1] VDD VSS dec_line_bit gf180mcu_fd_sc_mcu9t5v0__nor2_1
X\_172_ line_state[0] line_state[1] VDD VSS dec_line_valid gf180mcu_fd_sc_mcu9t5v0__xor2_1
X\_173_ tx_state[3] \_055_ tx_state[0] VDD VSS \_067_ gf180mcu_fd_sc_mcu9t5v0__aoi21_1
X\_174_ \_067_ VDD VSS TxReady gf180mcu_fd_sc_mcu9t5v0__clkinv_1
X\_175_ cur_byte[3] VDD VSS \_068_ gf180mcu_fd_sc_mcu9t5v0__clkinv_1
X\_176_ cur_byte[7] VDD VSS \_069_ gf180mcu_fd_sc_mcu9t5v0__clkinv_1
X\_177_ cur_byte[1] VDD VSS \_070_ gf180mcu_fd_sc_mcu9t5v0__clkinv_1
X\_178_ cur_byte[5] VDD VSS \_071_ gf180mcu_fd_sc_mcu9t5v0__clkinv_1
X\_179_ tx_bitidx[1] VDD VSS \_072_ gf180mcu_fd_sc_mcu9t5v0__clkinv_1
X\_180_ \_068_ \_069_ \_070_ \_071_ tx_bitidx[2] \_072_ VDD VSS \_073_ gf180mcu_fd_sc_mcu9t5v0__mux4_1
X\_181_ cur_byte[0] cur_byte[4] cur_byte[2] cur_byte[6] tx_bitidx[2] tx_bitidx[1] VDD VSS \_074_ gf180mcu_fd_sc_mcu9t5v0__mux4_1
X\_182_ tx_bitidx[0] \_074_ VDD VSS \_075_ gf180mcu_fd_sc_mcu9t5v0__nor2_1
X\_183_ tx_bitidx[0] \_073_ \_075_ \_056_ VDD VSS stuffer_in_bit gf180mcu_fd_sc_mcu9t5v0__aoi211_1
X\_184_ stuff_in_ready \_058_ \_056_ VDD VSS stuffer_in_valid gf180mcu_fd_sc_mcu9t5v0__oai21_1
X\_185_ tx_state[8] int_rst_n VDD VSS \_000_ gf180mcu_fd_sc_mcu9t5v0__and2_1
X\_186_ tx_state[3] TxValid tx_state[0] VDD VSS \_076_ gf180mcu_fd_sc_mcu9t5v0__mux2_2
X\_187_ \_056_ \_055_ \_076_ VDD VSS \_077_ gf180mcu_fd_sc_mcu9t5v0__oai21_4
X\_188_ \_057_ \_077_ VDD VSS \_078_ gf180mcu_fd_sc_mcu9t5v0__or2_2
X\_190_ next_byte[1] tx_state[3] \_057_ \_077_ VDD VSS \_080_ gf180mcu_fd_sc_mcu9t5v0__aoi211_2
X\_192_ \_070_ \_078_ \_080_ \_054_ VDD VSS \_010_ gf180mcu_fd_sc_mcu9t5v0__aoi211_2
X\_193_ cur_byte[0] VDD VSS \_082_ gf180mcu_fd_sc_mcu9t5v0__clkinv_1
X\_194_ next_byte[0] tx_state[3] \_057_ \_077_ VDD VSS \_083_ gf180mcu_fd_sc_mcu9t5v0__aoi211_2
X\_195_ \_082_ \_078_ \_083_ \_054_ VDD VSS \_011_ gf180mcu_fd_sc_mcu9t5v0__aoi211_2
X\_196_ tx_state[3] tx_state[0] TxValid VDD VSS \_084_ gf180mcu_fd_sc_mcu9t5v0__oai21_1
X\_197_ tx_state[3] \_061_ \_084_ VDD VSS \_085_ gf180mcu_fd_sc_mcu9t5v0__aoi21_2
X\_198_ DataOut[6] \_085_ VDD VSS \_086_ gf180mcu_fd_sc_mcu9t5v0__nand2_1
X\_199_ tx_state[3] tx_state[0] VDD VSS \_087_ gf180mcu_fd_sc_mcu9t5v0__or2_1
X\_200_ \_056_ \_055_ \_087_ TxValid VDD VSS \_088_ gf180mcu_fd_sc_mcu9t5v0__oai211_2
X\_201_ next_byte[6] \_088_ VDD VSS \_089_ gf180mcu_fd_sc_mcu9t5v0__nand2_1
X\_202_ \_086_ \_089_ \_054_ VDD VSS \_012_ gf180mcu_fd_sc_mcu9t5v0__aoi21_1
X\_203_ DataOut[5] \_085_ VDD VSS \_090_ gf180mcu_fd_sc_mcu9t5v0__nand2_1
X\_204_ next_byte[5] \_088_ VDD VSS \_091_ gf180mcu_fd_sc_mcu9t5v0__nand2_1
X\_205_ \_090_ \_091_ \_054_ VDD VSS \_013_ gf180mcu_fd_sc_mcu9t5v0__aoi21_1
X\_206_ DataOut[4] \_085_ VDD VSS \_092_ gf180mcu_fd_sc_mcu9t5v0__nand2_1
X\_207_ next_byte[4] \_088_ VDD VSS \_093_ gf180mcu_fd_sc_mcu9t5v0__nand2_1
X\_208_ \_092_ \_093_ \_054_ VDD VSS \_014_ gf180mcu_fd_sc_mcu9t5v0__aoi21_1
X\_209_ DataOut[3] \_085_ VDD VSS \_094_ gf180mcu_fd_sc_mcu9t5v0__nand2_1
X\_210_ next_byte[3] \_088_ VDD VSS \_095_ gf180mcu_fd_sc_mcu9t5v0__nand2_1
X\_211_ \_094_ \_095_ \_054_ VDD VSS \_015_ gf180mcu_fd_sc_mcu9t5v0__aoi21_1
X\_212_ DataOut[2] \_085_ VDD VSS \_096_ gf180mcu_fd_sc_mcu9t5v0__nand2_1
X\_213_ next_byte[2] \_088_ VDD VSS \_097_ gf180mcu_fd_sc_mcu9t5v0__nand2_1
X\_214_ \_096_ \_097_ \_054_ VDD VSS \_016_ gf180mcu_fd_sc_mcu9t5v0__aoi21_1
X\_215_ DataOut[1] \_085_ VDD VSS \_098_ gf180mcu_fd_sc_mcu9t5v0__nand2_1
X\_216_ next_byte[1] \_088_ VDD VSS \_099_ gf180mcu_fd_sc_mcu9t5v0__nand2_1
X\_217_ \_098_ \_099_ \_054_ VDD VSS \_017_ gf180mcu_fd_sc_mcu9t5v0__aoi21_1
X\_218_ DataOut[0] \_085_ VDD VSS \_100_ gf180mcu_fd_sc_mcu9t5v0__nand2_1
X\_219_ next_byte[0] \_088_ VDD VSS \_101_ gf180mcu_fd_sc_mcu9t5v0__nand2_1
X\_220_ \_100_ \_101_ \_054_ VDD VSS \_018_ gf180mcu_fd_sc_mcu9t5v0__aoi21_1
X\_221_ tx_bitidx[0] VDD VSS \_102_ gf180mcu_fd_sc_mcu9t5v0__clkinv_1
X\_222_ \_056_ stuff_in_ready \_076_ VDD VSS \_103_ gf180mcu_fd_sc_mcu9t5v0__oai21_1
X\_223_ \_102_ \_103_ VDD VSS \_104_ gf180mcu_fd_sc_mcu9t5v0__or2_2
X\_224_ tx_bitidx[0] tx_bitidx[1] VDD VSS \_105_ gf180mcu_fd_sc_mcu9t5v0__nand2_1
X\_225_ tx_state[3] \_105_ \_103_ VDD VSS \_106_ gf180mcu_fd_sc_mcu9t5v0__aoi21_1
X\_226_ \_072_ \_104_ \_106_ \_054_ VDD VSS \_019_ gf180mcu_fd_sc_mcu9t5v0__aoi211_2
X\_227_ tx_bitidx[2] VDD VSS \_107_ gf180mcu_fd_sc_mcu9t5v0__clkinv_1
X\_228_ \_105_ \_103_ \_107_ VDD VSS \_108_ gf180mcu_fd_sc_mcu9t5v0__oai21_1
X\_229_ int_rst_n \_077_ \_108_ VDD VSS \_020_ gf180mcu_fd_sc_mcu9t5v0__and3_1
X\_230_ \_056_ \_103_ \_102_ VDD VSS \_109_ gf180mcu_fd_sc_mcu9t5v0__oai21_1
X\_231_ int_rst_n \_104_ \_109_ VDD VSS \_021_ gf180mcu_fd_sc_mcu9t5v0__and3_1
X\_232_ rx_bitcnt[0] destuff_out_valid rx_bitcnt[1] VDD VSS \_110_ gf180mcu_fd_sc_mcu9t5v0__and3_1
X\_233_ \_009_ \_053_ Reset VDD VSS \_111_ gf180mcu_fd_sc_mcu9t5v0__nor3_2
X\_235_ rx_bitcnt[2] \_110_ \_111_ VDD VSS \_113_ gf180mcu_fd_sc_mcu9t5v0__oai21_1
X\_236_ rx_bitcnt[2] \_110_ \_113_ VDD VSS \_022_ gf180mcu_fd_sc_mcu9t5v0__aoi21_1
X\_237_ rx_bitcnt[2] \_110_ \_111_ VDD VSS \_114_ gf180mcu_fd_sc_mcu9t5v0__nand3_2
X\_238_ rx_shift[7] DataIn[6] \_114_ VDD VSS \_023_ gf180mcu_fd_sc_mcu9t5v0__mux2_1
X\_240_ rx_shift[7] destuff_out_bit destuff_out_valid VDD VSS \_116_ gf180mcu_fd_sc_mcu9t5v0__mux2_1
X\_241_ \_111_ \_116_ VDD VSS \_024_ gf180mcu_fd_sc_mcu9t5v0__and2_1
X\_242_ rx_shift[6] DataIn[5] \_114_ VDD VSS \_025_ gf180mcu_fd_sc_mcu9t5v0__mux2_1
X\_243_ next_byte[7] \_056_ \_057_ \_077_ VDD VSS \_117_ gf180mcu_fd_sc_mcu9t5v0__nor4_2
X\_244_ \_069_ \_078_ \_117_ \_054_ VDD VSS \_026_ gf180mcu_fd_sc_mcu9t5v0__aoi211_2
X\_245_ rx_shift[5] DataIn[4] \_114_ VDD VSS \_027_ gf180mcu_fd_sc_mcu9t5v0__mux2_1
X\_246_ rx_shift[4] DataIn[3] \_114_ VDD VSS \_028_ gf180mcu_fd_sc_mcu9t5v0__mux2_1
X\_247_ rx_shift[3] DataIn[2] \_114_ VDD VSS \_029_ gf180mcu_fd_sc_mcu9t5v0__mux2_1
X\_248_ destuff_out_bit DataIn[7] \_114_ VDD VSS \_030_ gf180mcu_fd_sc_mcu9t5v0__mux2_1
X\_249_ rx_shift[2] DataIn[1] \_114_ VDD VSS \_031_ gf180mcu_fd_sc_mcu9t5v0__mux2_1
X\_250_ tx_state[4] tx_state[8] VDD VSS \_118_ gf180mcu_fd_sc_mcu9t5v0__nor2_1
X\_251_ txdp VDD VSS \_119_ gf180mcu_fd_sc_mcu9t5v0__clkinv_1
X\_252_ enc_line_valid enc_line_bit VDD VSS \_120_ gf180mcu_fd_sc_mcu9t5v0__nand2_1
X\_253_ enc_line_valid \_119_ \_120_ VDD VSS \_121_ gf180mcu_fd_sc_mcu9t5v0__oai21_1
X\_254_ \_118_ \_121_ VDD VSS \_122_ gf180mcu_fd_sc_mcu9t5v0__nand2_1
X\_255_ \_065_ \_122_ VDD VSS \_032_ gf180mcu_fd_sc_mcu9t5v0__nand2_1
X\_256_ rx_shift[1] DataIn[0] \_114_ VDD VSS \_033_ gf180mcu_fd_sc_mcu9t5v0__mux2_1
X\_257_ DataOut[7] \_085_ VDD VSS \_123_ gf180mcu_fd_sc_mcu9t5v0__nand2_1
X\_258_ next_byte[7] \_088_ VDD VSS \_124_ gf180mcu_fd_sc_mcu9t5v0__nand2_1
X\_259_ \_123_ \_124_ \_054_ VDD VSS \_034_ gf180mcu_fd_sc_mcu9t5v0__aoi21_1
X\_260_ \_114_ VDD VSS \_035_ gf180mcu_fd_sc_mcu9t5v0__clkinv_1
X\_261_ next_valid \_077_ VDD VSS \_125_ gf180mcu_fd_sc_mcu9t5v0__nand2_1
X\_262_ \_088_ \_125_ \_054_ VDD VSS \_036_ gf180mcu_fd_sc_mcu9t5v0__aoi21_1
X\_263_ rx_shift[6] rx_shift[7] destuff_out_valid VDD VSS \_126_ gf180mcu_fd_sc_mcu9t5v0__mux2_1
X\_264_ \_111_ \_126_ VDD VSS \_037_ gf180mcu_fd_sc_mcu9t5v0__and2_1
X\_265_ rx_shift[5] rx_shift[6] destuff_out_valid VDD VSS \_127_ gf180mcu_fd_sc_mcu9t5v0__mux2_1
X\_266_ \_111_ \_127_ VDD VSS \_038_ gf180mcu_fd_sc_mcu9t5v0__and2_1
X\_267_ rx_shift[4] rx_shift[5] destuff_out_valid VDD VSS \_128_ gf180mcu_fd_sc_mcu9t5v0__mux2_1
X\_268_ \_111_ \_128_ VDD VSS \_039_ gf180mcu_fd_sc_mcu9t5v0__and2_1
X\_269_ rx_shift[3] rx_shift[4] destuff_out_valid VDD VSS \_129_ gf180mcu_fd_sc_mcu9t5v0__mux2_1
X\_270_ \_111_ \_129_ VDD VSS \_040_ gf180mcu_fd_sc_mcu9t5v0__and2_1
X\_271_ destuff_stuff_err \_111_ VDD VSS \_041_ gf180mcu_fd_sc_mcu9t5v0__and2_1
X\_272_ rx_shift[2] rx_shift[3] destuff_out_valid VDD VSS \_130_ gf180mcu_fd_sc_mcu9t5v0__mux2_1
X\_273_ \_111_ \_130_ VDD VSS \_042_ gf180mcu_fd_sc_mcu9t5v0__and2_1
X\_274_ rx_shift[1] rx_shift[2] destuff_out_valid VDD VSS \_131_ gf180mcu_fd_sc_mcu9t5v0__mux2_1
X\_275_ \_111_ \_131_ VDD VSS \_043_ gf180mcu_fd_sc_mcu9t5v0__and2_1
X\_276_ txdm enc_line_valid \_118_ \_120_ VDD VSS \_132_ gf180mcu_fd_sc_mcu9t5v0__oai211_1
X\_277_ tx_state[1] \_054_ \_132_ VDD VSS \_044_ gf180mcu_fd_sc_mcu9t5v0__nor3_1
X\_278_ rx_bitcnt[0] destuff_out_valid rx_bitcnt[1] VDD VSS \_133_ gf180mcu_fd_sc_mcu9t5v0__aoi21_1
X\_279_ \_009_ \_054_ \_110_ \_133_ VDD VSS \_045_ gf180mcu_fd_sc_mcu9t5v0__nor4_1
X\_280_ rx_bitcnt[0] destuff_out_valid \_111_ VDD VSS \_134_ gf180mcu_fd_sc_mcu9t5v0__oai21_1
X\_281_ rx_bitcnt[0] destuff_out_valid \_134_ VDD VSS \_046_ gf180mcu_fd_sc_mcu9t5v0__aoi21_1
X\_282_ cur_byte[6] VDD VSS \_135_ gf180mcu_fd_sc_mcu9t5v0__clkinv_1
X\_283_ next_byte[6] tx_state[3] \_057_ \_077_ VDD VSS \_136_ gf180mcu_fd_sc_mcu9t5v0__aoi211_2
X\_284_ \_135_ \_078_ \_136_ \_054_ VDD VSS \_047_ gf180mcu_fd_sc_mcu9t5v0__aoi211_2
X\_285_ next_byte[5] tx_state[3] \_057_ \_077_ VDD VSS \_137_ gf180mcu_fd_sc_mcu9t5v0__aoi211_2
X\_286_ \_071_ \_078_ \_137_ \_054_ VDD VSS \_048_ gf180mcu_fd_sc_mcu9t5v0__aoi211_2
X\_287_ \_009_ eop_pulse bus_reset VDD VSS \_138_ gf180mcu_fd_sc_mcu9t5v0__nor3_1
X\_288_ sync_next \_138_ VDD VSS \_139_ gf180mcu_fd_sc_mcu9t5v0__nor2_1
X\_289_ \_054_ \_139_ VDD VSS \_049_ gf180mcu_fd_sc_mcu9t5v0__nor2_1
X\_290_ cur_byte[4] VDD VSS \_140_ gf180mcu_fd_sc_mcu9t5v0__clkinv_1
X\_291_ next_byte[4] tx_state[3] \_057_ \_077_ VDD VSS \_141_ gf180mcu_fd_sc_mcu9t5v0__aoi211_2
X\_292_ \_140_ \_078_ \_141_ \_054_ VDD VSS \_050_ gf180mcu_fd_sc_mcu9t5v0__aoi211_2
X\_293_ next_byte[3] tx_state[3] \_057_ \_077_ VDD VSS \_142_ gf180mcu_fd_sc_mcu9t5v0__aoi211_2
X\_294_ \_068_ \_078_ \_142_ \_054_ VDD VSS \_051_ gf180mcu_fd_sc_mcu9t5v0__aoi211_2
X\_295_ cur_byte[2] VDD VSS \_143_ gf180mcu_fd_sc_mcu9t5v0__clkinv_1
X\_296_ next_byte[2] tx_state[3] \_057_ \_077_ VDD VSS \_144_ gf180mcu_fd_sc_mcu9t5v0__aoi211_2
X\_297_ \_143_ \_078_ \_144_ \_054_ VDD VSS \_052_ gf180mcu_fd_sc_mcu9t5v0__aoi211_2
X\_298_ clknet_3_4__leaf_clk \_018_ next_byte[0] VDD VSS gf180mcu_fd_sc_mcu9t5v0__dffq_1
X\_299_ clknet_3_4__leaf_clk \_017_ next_byte[1] VDD VSS gf180mcu_fd_sc_mcu9t5v0__dffq_1
X\_300_ clknet_3_4__leaf_clk \_016_ next_byte[2] VDD VSS gf180mcu_fd_sc_mcu9t5v0__dffq_1
X\_301_ clknet_3_5__leaf_clk \_015_ next_byte[3] VDD VSS gf180mcu_fd_sc_mcu9t5v0__dffq_1
X\_302_ clknet_3_4__leaf_clk \_014_ next_byte[4] VDD VSS gf180mcu_fd_sc_mcu9t5v0__dffq_1
X\_303_ clknet_3_4__leaf_clk \_013_ next_byte[5] VDD VSS gf180mcu_fd_sc_mcu9t5v0__dffq_1
X\_304_ clknet_3_4__leaf_clk \_012_ next_byte[6] VDD VSS gf180mcu_fd_sc_mcu9t5v0__dffq_1
X\_305_ clknet_3_4__leaf_clk \_034_ next_byte[7] VDD VSS gf180mcu_fd_sc_mcu9t5v0__dffq_1
X\_306_ clknet_3_0__leaf_clk \_046_ rx_bitcnt[0] VDD VSS gf180mcu_fd_sc_mcu9t5v0__dffq_1
X\_307_ clknet_3_0__leaf_clk \_045_ rx_bitcnt[1] VDD VSS gf180mcu_fd_sc_mcu9t5v0__dffq_1
X\_308_ clknet_3_0__leaf_clk \_022_ rx_bitcnt[2] VDD VSS gf180mcu_fd_sc_mcu9t5v0__dffq_1
X\_309_ clknet_3_1__leaf_clk \_043_ rx_shift[1] VDD VSS gf180mcu_fd_sc_mcu9t5v0__dffq_1
X\_310_ clknet_3_1__leaf_clk \_042_ rx_shift[2] VDD VSS gf180mcu_fd_sc_mcu9t5v0__dffq_1
X\_311_ clknet_3_1__leaf_clk \_040_ rx_shift[3] VDD VSS gf180mcu_fd_sc_mcu9t5v0__dffq_1
X\_312_ clknet_3_0__leaf_clk \_039_ rx_shift[4] VDD VSS gf180mcu_fd_sc_mcu9t5v0__dffq_1
X\_313_ clknet_3_0__leaf_clk \_038_ rx_shift[5] VDD VSS gf180mcu_fd_sc_mcu9t5v0__dffq_1
X\_314_ clknet_3_0__leaf_clk \_037_ rx_shift[6] VDD VSS gf180mcu_fd_sc_mcu9t5v0__dffq_1
X\_315_ clknet_3_0__leaf_clk \_024_ rx_shift[7] VDD VSS gf180mcu_fd_sc_mcu9t5v0__dffq_1
X\_316_ clknet_3_1__leaf_clk \_033_ DataIn[0] VDD VSS gf180mcu_fd_sc_mcu9t5v0__dffq_1
X\_317_ clknet_3_1__leaf_clk \_031_ DataIn[1] VDD VSS gf180mcu_fd_sc_mcu9t5v0__dffq_1
X\_318_ clknet_3_1__leaf_clk \_029_ DataIn[2] VDD VSS gf180mcu_fd_sc_mcu9t5v0__dffq_1
X\_319_ clknet_3_1__leaf_clk \_028_ DataIn[3] VDD VSS gf180mcu_fd_sc_mcu9t5v0__dffq_1
X\_320_ clknet_3_0__leaf_clk \_027_ DataIn[4] VDD VSS gf180mcu_fd_sc_mcu9t5v0__dffq_1
X\_321_ clknet_3_0__leaf_clk \_025_ DataIn[5] VDD VSS gf180mcu_fd_sc_mcu9t5v0__dffq_1
X\_322_ clknet_3_0__leaf_clk \_023_ DataIn[6] VDD VSS gf180mcu_fd_sc_mcu9t5v0__dffq_1
X\_323_ clknet_3_0__leaf_clk \_030_ DataIn[7] VDD VSS gf180mcu_fd_sc_mcu9t5v0__dffq_1
X\_324_ clknet_3_1__leaf_clk \_035_ RxValid VDD VSS gf180mcu_fd_sc_mcu9t5v0__dffq_1
X\_325_ clknet_3_1__leaf_clk \_041_ RxError VDD VSS gf180mcu_fd_sc_mcu9t5v0__dffq_1
X\_326_ clknet_3_3__leaf_clk \_049_ rx_receiving VDD VSS gf180mcu_fd_sc_mcu9t5v0__dffq_1
X\_327_ clknet_3_7__leaf_clk \_021_ tx_bitidx[0] VDD VSS gf180mcu_fd_sc_mcu9t5v0__dffq_1
X\_328_ clknet_3_7__leaf_clk \_019_ tx_bitidx[1] VDD VSS gf180mcu_fd_sc_mcu9t5v0__dffq_1
X\_329_ clknet_3_5__leaf_clk \_020_ tx_bitidx[2] VDD VSS gf180mcu_fd_sc_mcu9t5v0__dffq_1
X\_330_ clknet_3_5__leaf_clk \_011_ cur_byte[0] VDD VSS gf180mcu_fd_sc_mcu9t5v0__dffq_1
X\_331_ clknet_3_5__leaf_clk \_010_ cur_byte[1] VDD VSS gf180mcu_fd_sc_mcu9t5v0__dffq_1
X\_332_ clknet_3_5__leaf_clk \_052_ cur_byte[2] VDD VSS gf180mcu_fd_sc_mcu9t5v0__dffq_1
X\_333_ clknet_3_5__leaf_clk \_051_ cur_byte[3] VDD VSS gf180mcu_fd_sc_mcu9t5v0__dffq_1
X\_334_ clknet_3_5__leaf_clk \_050_ cur_byte[4] VDD VSS gf180mcu_fd_sc_mcu9t5v0__dffq_1
X\_335_ clknet_3_5__leaf_clk \_048_ cur_byte[5] VDD VSS gf180mcu_fd_sc_mcu9t5v0__dffq_1
X\_336_ clknet_3_5__leaf_clk \_047_ cur_byte[6] VDD VSS gf180mcu_fd_sc_mcu9t5v0__dffq_1
X\_337_ clknet_3_5__leaf_clk \_026_ cur_byte[7] VDD VSS gf180mcu_fd_sc_mcu9t5v0__dffq_1
X\_338_ clknet_3_3__leaf_clk \_032_ txdp VDD VSS gf180mcu_fd_sc_mcu9t5v0__dffq_1
X\_339_ clknet_3_5__leaf_clk \_036_ next_valid VDD VSS gf180mcu_fd_sc_mcu9t5v0__dffq_1
X\_340_ clknet_3_3__leaf_clk \_044_ txdm VDD VSS gf180mcu_fd_sc_mcu9t5v0__dffq_1
X\_341_ clknet_3_6__leaf_clk \_007_ tx_state[0] VDD VSS gf180mcu_fd_sc_mcu9t5v0__dffq_1
X\_342_ clknet_3_3__leaf_clk \_000_ tx_state[1] VDD VSS gf180mcu_fd_sc_mcu9t5v0__dffq_1
X\_343_ clknet_3_7__leaf_clk \_001_ tx_state[2] VDD VSS gf180mcu_fd_sc_mcu9t5v0__dffq_1
X\_344_ clknet_3_7__leaf_clk \_008_ tx_state[3] VDD VSS gf180mcu_fd_sc_mcu9t5v0__dffq_1
X\_345_ clknet_3_6__leaf_clk \_002_ tx_state[4] VDD VSS gf180mcu_fd_sc_mcu9t5v0__dffq_1
X\_346_ clknet_3_6__leaf_clk \_003_ tx_state[5] VDD VSS gf180mcu_fd_sc_mcu9t5v0__dffq_1
X\_347_ clknet_3_6__leaf_clk \_004_ tx_state[6] VDD VSS gf180mcu_fd_sc_mcu9t5v0__dffq_1
X\_348_ clknet_3_7__leaf_clk \_005_ tx_state[7] VDD VSS gf180mcu_fd_sc_mcu9t5v0__dffq_1
X\_349_ clknet_3_3__leaf_clk \_006_ tx_state[8] VDD VSS gf180mcu_fd_sc_mcu9t5v0__dffq_1
X\_350_ VDD VSS \_145_ gf180mcu_fd_sc_mcu9t5v0__tiel
Xclkbuf_0_clk clk VDD VSS clknet_0_clk gf180mcu_fd_sc_mcu9t5v0__buf_4
Xclkbuf_3_0__f_clk clknet_0_clk VDD VSS clknet_3_0__leaf_clk gf180mcu_fd_sc_mcu9t5v0__buf_4
Xclkbuf_3_1__f_clk clknet_0_clk VDD VSS clknet_3_1__leaf_clk gf180mcu_fd_sc_mcu9t5v0__buf_4
Xclkbuf_3_2__f_clk clknet_0_clk VDD VSS clknet_3_2__leaf_clk gf180mcu_fd_sc_mcu9t5v0__buf_4
Xclkbuf_3_3__f_clk clknet_0_clk VDD VSS clknet_3_3__leaf_clk gf180mcu_fd_sc_mcu9t5v0__buf_4
Xclkbuf_3_4__f_clk clknet_0_clk VDD VSS clknet_3_4__leaf_clk gf180mcu_fd_sc_mcu9t5v0__buf_4
Xclkbuf_3_5__f_clk clknet_0_clk VDD VSS clknet_3_5__leaf_clk gf180mcu_fd_sc_mcu9t5v0__buf_4
Xclkbuf_3_6__f_clk clknet_0_clk VDD VSS clknet_3_6__leaf_clk gf180mcu_fd_sc_mcu9t5v0__buf_4
Xclkbuf_3_7__f_clk clknet_0_clk VDD VSS clknet_3_7__leaf_clk gf180mcu_fd_sc_mcu9t5v0__buf_4
Xclkload0 clknet_3_1__leaf_clk VDD VSS clkload0/ZN.unconnected gf180mcu_fd_sc_mcu9t5v0__inv_4
Xclkload1 clknet_3_2__leaf_clk VDD VSS clkload1/ZN.unconnected gf180mcu_fd_sc_mcu9t5v0__inv_3
Xclkload2 clknet_3_3__leaf_clk VDD VSS clkload2/ZN.unconnected gf180mcu_fd_sc_mcu9t5v0__clkinv_3
Xclkload3 clknet_3_4__leaf_clk VDD VSS clkload3/ZN.unconnected gf180mcu_fd_sc_mcu9t5v0__clkinv_8
Xclkload4 clknet_3_5__leaf_clk VDD VSS clkload4/ZN.unconnected gf180mcu_fd_sc_mcu9t5v0__inv_3
Xclkload5 clknet_3_6__leaf_clk VDD VSS clkload5/ZN.unconnected gf180mcu_fd_sc_mcu9t5v0__clkinv_8
Xclkload6 clknet_3_7__leaf_clk VDD VSS clkload6/ZN.unconnected gf180mcu_fd_sc_mcu9t5v0__inv_4
Xu_decoder/_09_ u_decoder/prev_line dec_line_bit VDD VSS u_decoder/_03_ gf180mcu_fd_sc_mcu9t5v0__xor2_2
Xu_decoder/_10_ \_145_ VDD VSS u_decoder/_04_ gf180mcu_fd_sc_mcu9t5v0__clkinv_1
Xu_decoder/_11_ dec_line_valid dec_data_bit u_decoder/_04_ int_rst_n VDD VSS u_decoder/_05_ gf180mcu_fd_sc_mcu9t5v0__oai211_1
Xu_decoder/_12_ dec_line_valid u_decoder/_03_ u_decoder/_05_ VDD VSS u_decoder/_00_ gf180mcu_fd_sc_mcu9t5v0__aoi21_2
Xu_decoder/_13_ u_decoder/prev_line VDD VSS u_decoder/_06_ gf180mcu_fd_sc_mcu9t5v0__clkinv_1
Xu_decoder/_14_ u_decoder/_04_ int_rst_n VDD VSS u_decoder/_07_ gf180mcu_fd_sc_mcu9t5v0__and2_1
Xu_decoder/_15_ dec_line_bit dec_line_valid VDD VSS u_decoder/_08_ gf180mcu_fd_sc_mcu9t5v0__nand2_1
Xu_decoder/_16_ u_decoder/_06_ dec_line_valid u_decoder/_07_ u_decoder/_08_ VDD VSS u_decoder/_01_ gf180mcu_fd_sc_mcu9t5v0__oai211_1
Xu_decoder/_17_ dec_line_valid u_decoder/_07_ VDD VSS u_decoder/_02_ gf180mcu_fd_sc_mcu9t5v0__and2_1
Xu_decoder/_18_ clknet_3_3__leaf_clk u_decoder/_01_ u_decoder/prev_line VDD VSS gf180mcu_fd_sc_mcu9t5v0__dffq_1
Xu_decoder/_19_ clknet_3_2__leaf_clk u_decoder/_00_ dec_data_bit VDD VSS gf180mcu_fd_sc_mcu9t5v0__dffq_1
Xu_decoder/_20_ clknet_3_2__leaf_clk u_decoder/_02_ dec_data_valid VDD VSS gf180mcu_fd_sc_mcu9t5v0__dffq_1
Xu_destuffer/_22_ u_destuffer/ones[2] u_destuffer/ones[1] VDD VSS u_destuffer/_06_ gf180mcu_fd_sc_mcu9t5v0__nand2_4
Xu_destuffer/_23_ sync_next VDD VSS u_destuffer/_07_ gf180mcu_fd_sc_mcu9t5v0__inv_3
Xu_destuffer/_24_ dec_data_bit destuff_in_valid u_destuffer/_07_ int_rst_n VDD VSS u_destuffer/_08_ gf180mcu_fd_sc_mcu9t5v0__nand4_4
Xu_destuffer/_25_ u_destuffer/ones[0] u_destuffer/_06_ u_destuffer/_08_ VDD VSS u_destuffer/_00_ gf180mcu_fd_sc_mcu9t5v0__nor3_1
Xu_destuffer/_26_ u_destuffer/_07_ int_rst_n VDD VSS u_destuffer/_09_ gf180mcu_fd_sc_mcu9t5v0__nand2_2
Xu_destuffer/_27_ destuff_in_valid VDD VSS u_destuffer/_10_ gf180mcu_fd_sc_mcu9t5v0__inv_4
Xu_destuffer/_28_ dec_data_bit u_destuffer/_06_ u_destuffer/_10_ VDD VSS u_destuffer/_11_ gf180mcu_fd_sc_mcu9t5v0__aoi21_4
Xu_destuffer/_29_ destuff_in_valid u_destuffer/ones[0] VDD VSS u_destuffer/_12_ gf180mcu_fd_sc_mcu9t5v0__xnor2_1
Xu_destuffer/_30_ u_destuffer/_09_ u_destuffer/_11_ u_destuffer/_12_ VDD VSS u_destuffer/_01_ gf180mcu_fd_sc_mcu9t5v0__nor3_2
Xu_destuffer/_31_ destuff_in_valid u_destuffer/ones[0] VDD VSS u_destuffer/_13_ gf180mcu_fd_sc_mcu9t5v0__nand2_4
Xu_destuffer/_32_ u_destuffer/ones[1] u_destuffer/_13_ VDD VSS u_destuffer/_14_ gf180mcu_fd_sc_mcu9t5v0__xor2_2
Xu_destuffer/_33_ u_destuffer/_09_ u_destuffer/_11_ u_destuffer/_14_ VDD VSS u_destuffer/_02_ gf180mcu_fd_sc_mcu9t5v0__nor3_2
Xu_destuffer/_34_ u_destuffer/ones[2] VDD VSS u_destuffer/_15_ gf180mcu_fd_sc_mcu9t5v0__clkinv_1
Xu_destuffer/_35_ destuff_in_valid u_destuffer/ones[1] u_destuffer/ones[0] VDD VSS u_destuffer/_16_ gf180mcu_fd_sc_mcu9t5v0__nand3_1
Xu_destuffer/_36_ u_destuffer/_15_ u_destuffer/_16_ u_destuffer/_11_ u_destuffer/_09_ VDD VSS u_destuffer/_03_ gf180mcu_fd_sc_mcu9t5v0__aoi211_2
Xu_destuffer/_37_ u_destuffer/ones[0] u_destuffer/_06_ VDD VSS u_destuffer/_17_ gf180mcu_fd_sc_mcu9t5v0__nor2_2
Xu_destuffer/_38_ u_destuffer/_10_ u_destuffer/_17_ u_destuffer/_09_ VDD VSS u_destuffer/_04_ gf180mcu_fd_sc_mcu9t5v0__nor3_1
Xu_destuffer/_39_ destuff_out_bit VDD VSS u_destuffer/_18_ gf180mcu_fd_sc_mcu9t5v0__clkinv_1
Xu_destuffer/_40_ u_destuffer/ones[0] VDD VSS u_destuffer/_19_ gf180mcu_fd_sc_mcu9t5v0__clkinv_2
Xu_destuffer/_41_ u_destuffer/ones[2] u_destuffer/ones[1] VDD VSS u_destuffer/_20_ gf180mcu_fd_sc_mcu9t5v0__and2_4
Xu_destuffer/_42_ u_destuffer/_19_ u_destuffer/_20_ u_destuffer/_10_ VDD VSS u_destuffer/_21_ gf180mcu_fd_sc_mcu9t5v0__aoi21_4
Xu_destuffer/_43_ u_destuffer/_18_ u_destuffer/_09_ u_destuffer/_21_ u_destuffer/_08_ u_destuffer/_17_ VDD VSS u_destuffer/_05_ gf180mcu_fd_sc_mcu9t5v0__oai32_4
Xu_destuffer/_44_ clknet_3_0__leaf_clk u_destuffer/_00_ destuff_stuff_err VDD VSS gf180mcu_fd_sc_mcu9t5v0__dffq_1
Xu_destuffer/_45_ clknet_3_2__leaf_clk u_destuffer/_01_ u_destuffer/ones[0] VDD VSS gf180mcu_fd_sc_mcu9t5v0__dffq_1
Xu_destuffer/_46_ clknet_3_2__leaf_clk u_destuffer/_02_ u_destuffer/ones[1] VDD VSS gf180mcu_fd_sc_mcu9t5v0__dffq_1
Xu_destuffer/_47_ clknet_3_0__leaf_clk u_destuffer/_03_ u_destuffer/ones[2] VDD VSS gf180mcu_fd_sc_mcu9t5v0__dffq_1
Xu_destuffer/_48_ clknet_3_0__leaf_clk u_destuffer/_05_ destuff_out_bit VDD VSS gf180mcu_fd_sc_mcu9t5v0__dffq_1
Xu_destuffer/_49_ clknet_3_0__leaf_clk u_destuffer/_04_ destuff_out_valid VDD VSS gf180mcu_fd_sc_mcu9t5v0__dffq_1
Xu_encoder/_07_ stuff_out_valid VDD VSS u_encoder/_05_ gf180mcu_fd_sc_mcu9t5v0__inv_2
Xu_encoder/_08_ u_encoder/_05_ stuff_out_bit enc_line_bit VDD VSS u_encoder/_06_ gf180mcu_fd_sc_mcu9t5v0__oai21_1
Xu_encoder/_09_ enc_line_bit u_encoder/_05_ stuff_out_bit VDD VSS u_encoder/_02_ gf180mcu_fd_sc_mcu9t5v0__or3_4
Xu_encoder/_10_ int_rst_n VDD VSS u_encoder/_03_ gf180mcu_fd_sc_mcu9t5v0__inv_1
Xu_encoder/_11_ tx_state[5] u_encoder/_03_ VDD VSS u_encoder/_04_ gf180mcu_fd_sc_mcu9t5v0__nor2_1
Xu_encoder/_12_ u_encoder/_06_ u_encoder/_02_ u_encoder/_04_ VDD VSS u_encoder/_00_ gf180mcu_fd_sc_mcu9t5v0__nand3_2
Xu_encoder/_13_ u_encoder/_05_ tx_state[5] u_encoder/_03_ VDD VSS u_encoder/_01_ gf180mcu_fd_sc_mcu9t5v0__nor3_1
Xu_encoder/_14_ clknet_3_6__leaf_clk u_encoder/_00_ enc_line_bit VDD VSS gf180mcu_fd_sc_mcu9t5v0__dffq_1
Xu_encoder/_15_ clknet_3_6__leaf_clk u_encoder/_01_ enc_line_valid VDD VSS gf180mcu_fd_sc_mcu9t5v0__dffq_1
Xu_eop_detector/_27_ line_state[0] line_state[1] VDD VSS u_eop_detector/_08_ gf180mcu_fd_sc_mcu9t5v0__nor2_1
Xu_eop_detector/_28_ int_rst_n u_eop_detector/_08_ VDD VSS u_eop_detector/_09_ gf180mcu_fd_sc_mcu9t5v0__nand2_1
Xu_eop_detector/_29_ u_eop_detector/se0_count[3] u_eop_detector/se0_count[4] u_eop_detector/se0_count[2] VDD VSS u_eop_detector/_10_ gf180mcu_fd_sc_mcu9t5v0__and3_4
Xu_eop_detector/_30_ u_eop_detector/se0_count[0] VDD VSS u_eop_detector/_11_ gf180mcu_fd_sc_mcu9t5v0__clkinv_1
Xu_eop_detector/_31_ u_eop_detector/se0_count[5] u_eop_detector/_11_ u_eop_detector/se0_count[1] VDD VSS u_eop_detector/_12_ gf180mcu_fd_sc_mcu9t5v0__nor3_1
Xu_eop_detector/_32_ u_eop_detector/_10_ u_eop_detector/_12_ bus_reset VDD VSS u_eop_detector/_13_ gf180mcu_fd_sc_mcu9t5v0__aoi21_1
Xu_eop_detector/_33_ u_eop_detector/_09_ u_eop_detector/_13_ VDD VSS u_eop_detector/_00_ gf180mcu_fd_sc_mcu9t5v0__nor2_1
Xu_eop_detector/_34_ u_eop_detector/se0_count[1] VDD VSS u_eop_detector/_14_ gf180mcu_fd_sc_mcu9t5v0__inv_1
Xu_eop_detector/_35_ u_eop_detector/se0_count[5] u_eop_detector/_11_ u_eop_detector/_14_ u_eop_detector/_10_ VDD VSS u_eop_detector/_15_ gf180mcu_fd_sc_mcu9t5v0__nor4_4
Xu_eop_detector/_36_ u_eop_detector/se0_count[2] u_eop_detector/_15_ VDD VSS u_eop_detector/_16_ gf180mcu_fd_sc_mcu9t5v0__xnor2_1
Xu_eop_detector/_37_ u_eop_detector/_09_ u_eop_detector/_16_ VDD VSS u_eop_detector/_01_ gf180mcu_fd_sc_mcu9t5v0__nor2_2
Xu_eop_detector/_38_ u_eop_detector/se0_count[5] VDD VSS u_eop_detector/_17_ gf180mcu_fd_sc_mcu9t5v0__clkinv_1
Xu_eop_detector/_39_ u_eop_detector/_17_ u_eop_detector/se0_count[0] VDD VSS u_eop_detector/_18_ gf180mcu_fd_sc_mcu9t5v0__nand2_1
Xu_eop_detector/_40_ u_eop_detector/_14_ u_eop_detector/_18_ u_eop_detector/_15_ u_eop_detector/_09_ VDD VSS u_eop_detector/_02_ gf180mcu_fd_sc_mcu9t5v0__aoi211_1
Xu_eop_detector/_41_ u_eop_detector/se0_count[1] u_eop_detector/_10_ u_eop_detector/_18_ VDD VSS u_eop_detector/_19_ gf180mcu_fd_sc_mcu9t5v0__aoi21_1
Xu_eop_detector/_42_ u_eop_detector/se0_count[1] u_eop_detector/_10_ VDD VSS u_eop_detector/_20_ gf180mcu_fd_sc_mcu9t5v0__nand2_1
Xu_eop_detector/_43_ u_eop_detector/_17_ u_eop_detector/_20_ u_eop_detector/se0_count[0] VDD VSS u_eop_detector/_21_ gf180mcu_fd_sc_mcu9t5v0__aoi21_1
Xu_eop_detector/_44_ u_eop_detector/_09_ u_eop_detector/_19_ u_eop_detector/_21_ VDD VSS u_eop_detector/_03_ gf180mcu_fd_sc_mcu9t5v0__nor3_1
Xu_eop_detector/_45_ u_eop_detector/se0_count[4] VDD VSS u_eop_detector/_22_ gf180mcu_fd_sc_mcu9t5v0__clkinv_1
Xu_eop_detector/_46_ u_eop_detector/se0_count[3] u_eop_detector/se0_count[2] u_eop_detector/_15_ VDD VSS u_eop_detector/_23_ gf180mcu_fd_sc_mcu9t5v0__nand3_1
Xu_eop_detector/_47_ u_eop_detector/_22_ u_eop_detector/_23_ u_eop_detector/_09_ VDD VSS u_eop_detector/_04_ gf180mcu_fd_sc_mcu9t5v0__aoi21_1
Xu_eop_detector/_48_ u_eop_detector/se0_count[3] u_eop_detector/se0_count[2] u_eop_detector/_15_ VDD VSS u_eop_detector/_24_ gf180mcu_fd_sc_mcu9t5v0__and3_1
Xu_eop_detector/_49_ u_eop_detector/se0_count[2] u_eop_detector/_15_ u_eop_detector/se0_count[3] VDD VSS u_eop_detector/_25_ gf180mcu_fd_sc_mcu9t5v0__aoi21_1
Xu_eop_detector/_50_ u_eop_detector/_09_ u_eop_detector/_24_ u_eop_detector/_25_ VDD VSS u_eop_detector/_05_ gf180mcu_fd_sc_mcu9t5v0__nor3_1
Xu_eop_detector/_51_ u_eop_detector/_17_ u_eop_detector/_09_ VDD VSS u_eop_detector/_06_ gf180mcu_fd_sc_mcu9t5v0__nor2_1
Xu_eop_detector/_52_ u_eop_detector/se0_count[3] u_eop_detector/se0_count[4] u_eop_detector/se0_count[2] u_eop_detector/_09_ VDD VSS u_eop_detector/_26_ gf180mcu_fd_sc_mcu9t5v0__nor4_1
Xu_eop_detector/_53_ u_eop_detector/_12_ u_eop_detector/_26_ VDD VSS u_eop_detector/_07_ gf180mcu_fd_sc_mcu9t5v0__and2_1
Xu_eop_detector/_54_ clknet_3_3__leaf_clk u_eop_detector/_00_ bus_reset VDD VSS gf180mcu_fd_sc_mcu9t5v0__dffq_1
Xu_eop_detector/_55_ clknet_3_3__leaf_clk u_eop_detector/_07_ eop_pulse VDD VSS gf180mcu_fd_sc_mcu9t5v0__dffq_1
Xu_eop_detector/_56_ clknet_3_3__leaf_clk u_eop_detector/_03_ u_eop_detector/se0_count[0] VDD VSS gf180mcu_fd_sc_mcu9t5v0__dffq_1
Xu_eop_detector/_57_ clknet_3_3__leaf_clk u_eop_detector/_02_ u_eop_detector/se0_count[1] VDD VSS gf180mcu_fd_sc_mcu9t5v0__dffq_1
Xu_eop_detector/_58_ clknet_3_2__leaf_clk u_eop_detector/_01_ u_eop_detector/se0_count[2] VDD VSS gf180mcu_fd_sc_mcu9t5v0__dffq_1
Xu_eop_detector/_59_ clknet_3_2__leaf_clk u_eop_detector/_05_ u_eop_detector/se0_count[3] VDD VSS gf180mcu_fd_sc_mcu9t5v0__dffq_1
Xu_eop_detector/_60_ clknet_3_2__leaf_clk u_eop_detector/_04_ u_eop_detector/se0_count[4] VDD VSS gf180mcu_fd_sc_mcu9t5v0__dffq_1
Xu_eop_detector/_61_ clknet_3_3__leaf_clk u_eop_detector/_06_ u_eop_detector/se0_count[5] VDD VSS gf180mcu_fd_sc_mcu9t5v0__dffq_1
Xu_line_state/_3_ rxdp VDD VSS u_line_state/_2_ gf180mcu_fd_sc_mcu9t5v0__inv_2
Xu_line_state/_4_ u_line_state/_2_ int_rst_n VDD VSS u_line_state/_0_ gf180mcu_fd_sc_mcu9t5v0__nand2_1
Xu_line_state/_5_ int_rst_n rxdm VDD VSS u_line_state/_1_ gf180mcu_fd_sc_mcu9t5v0__and2_4
Xu_line_state/_6_ clknet_3_1__leaf_clk u_line_state/_0_ line_state[0] VDD VSS gf180mcu_fd_sc_mcu9t5v0__dffq_1
Xu_line_state/_7_ clknet_3_4__leaf_clk u_line_state/_1_ line_state[1] VDD VSS gf180mcu_fd_sc_mcu9t5v0__dffq_1
Xu_stuffer/_19_ u_stuffer/ones[2] u_stuffer/ones[1] VDD VSS u_stuffer/_06_ gf180mcu_fd_sc_mcu9t5v0__nand2_4
Xu_stuffer/_20_ u_stuffer/ones[0] u_stuffer/_06_ VDD VSS stuff_in_ready gf180mcu_fd_sc_mcu9t5v0__or2_2
Xu_stuffer/_21_ stuffer_in_bit u_stuffer/_06_ VDD VSS u_stuffer/_07_ gf180mcu_fd_sc_mcu9t5v0__nand2_1
Xu_stuffer/_22_ stuffer_in_valid u_stuffer/ones[0] VDD VSS u_stuffer/_08_ gf180mcu_fd_sc_mcu9t5v0__nand2_4
Xu_stuffer/_23_ u_stuffer/ones[1] u_stuffer/_08_ VDD VSS u_stuffer/_09_ gf180mcu_fd_sc_mcu9t5v0__xor2_2
Xu_stuffer/_24_ tx_state[5] VDD VSS u_stuffer/_10_ gf180mcu_fd_sc_mcu9t5v0__inv_2
Xu_stuffer/_25_ u_stuffer/_10_ int_rst_n VDD VSS u_stuffer/_11_ gf180mcu_fd_sc_mcu9t5v0__nand2_2
Xu_stuffer/_26_ stuffer_in_valid u_stuffer/_07_ u_stuffer/_09_ u_stuffer/_11_ VDD VSS u_stuffer/_00_ gf180mcu_fd_sc_mcu9t5v0__aoi211_2
Xu_stuffer/_27_ stuffer_in_valid u_stuffer/ones[0] u_stuffer/ones[1] VDD VSS u_stuffer/_12_ gf180mcu_fd_sc_mcu9t5v0__nand3_1
Xu_stuffer/_28_ u_stuffer/ones[2] VDD VSS u_stuffer/_13_ gf180mcu_fd_sc_mcu9t5v0__clkinv_1
Xu_stuffer/_29_ stuffer_in_valid u_stuffer/_07_ u_stuffer/_12_ u_stuffer/_13_ u_stuffer/_11_ VDD VSS u_stuffer/_01_ gf180mcu_fd_sc_mcu9t5v0__aoi221_1
Xu_stuffer/_30_ u_stuffer/ones[0] u_stuffer/_06_ int_rst_n u_stuffer/_10_ VDD VSS u_stuffer/_14_ gf180mcu_fd_sc_mcu9t5v0__oai211_2
Xu_stuffer/_31_ stuffer_in_valid stuffer_in_bit u_stuffer/ones[0] VDD VSS u_stuffer/_15_ gf180mcu_fd_sc_mcu9t5v0__aoi21_1
Xu_stuffer/_32_ stuffer_in_valid u_stuffer/ones[0] u_stuffer/_14_ u_stuffer/_15_ VDD VSS u_stuffer/_02_ gf180mcu_fd_sc_mcu9t5v0__aoi211_1
Xu_stuffer/_33_ stuffer_in_valid stuffer_in_bit VDD VSS u_stuffer/_16_ gf180mcu_fd_sc_mcu9t5v0__nand2_1
Xu_stuffer/_34_ stuffer_in_valid VDD VSS u_stuffer/_17_ gf180mcu_fd_sc_mcu9t5v0__clkinv_1
Xu_stuffer/_35_ stuff_out_bit u_stuffer/_17_ VDD VSS u_stuffer/_18_ gf180mcu_fd_sc_mcu9t5v0__nand2_1
Xu_stuffer/_36_ u_stuffer/_14_ u_stuffer/_16_ u_stuffer/_18_ u_stuffer/_11_ VDD VSS u_stuffer/_03_ gf180mcu_fd_sc_mcu9t5v0__oai22_1
Xu_stuffer/_37_ u_stuffer/_17_ stuff_in_ready u_stuffer/_11_ VDD VSS u_stuffer/_04_ gf180mcu_fd_sc_mcu9t5v0__nor3_2
Xu_stuffer/_38_ u_stuffer/_17_ u_stuffer/_11_ VDD VSS u_stuffer/_05_ gf180mcu_fd_sc_mcu9t5v0__nor2_1
Xu_stuffer/_39_ clknet_3_7__leaf_clk u_stuffer/_02_ u_stuffer/ones[0] VDD VSS gf180mcu_fd_sc_mcu9t5v0__dffq_1
Xu_stuffer/_40_ clknet_3_7__leaf_clk u_stuffer/_00_ u_stuffer/ones[1] VDD VSS gf180mcu_fd_sc_mcu9t5v0__dffq_1
Xu_stuffer/_41_ clknet_3_7__leaf_clk u_stuffer/_01_ u_stuffer/ones[2] VDD VSS gf180mcu_fd_sc_mcu9t5v0__dffq_1
Xu_stuffer/_42_ clknet_3_7__leaf_clk u_stuffer/_04_ u_stuffer/out_stuffed VDD VSS gf180mcu_fd_sc_mcu9t5v0__dffq_1
Xu_stuffer/_43_ clknet_3_7__leaf_clk u_stuffer/_03_ stuff_out_bit VDD VSS gf180mcu_fd_sc_mcu9t5v0__dffq_1
Xu_stuffer/_44_ clknet_3_6__leaf_clk u_stuffer/_05_ stuff_out_valid VDD VSS gf180mcu_fd_sc_mcu9t5v0__dffq_1
Xu_sync_detector/_16_ \_009_ VDD VSS u_sync_detector/_05_ gf180mcu_fd_sc_mcu9t5v0__clkinv_1
Xu_sync_detector/_17_ u_sync_detector/match[0] u_sync_detector/match[1] u_sync_detector/match[2] VDD VSS u_sync_detector/_06_ gf180mcu_fd_sc_mcu9t5v0__nand3_4
Xu_sync_detector/_18_ dec_data_valid dec_data_bit VDD VSS u_sync_detector/_07_ gf180mcu_fd_sc_mcu9t5v0__nand2_4
Xu_sync_detector/_19_ u_sync_detector/match[3] u_sync_detector/_05_ u_sync_detector/_06_ u_sync_detector/_07_ VDD VSS sync_next gf180mcu_fd_sc_mcu9t5v0__nor4_4
Xu_sync_detector/_20_ u_sync_detector/match[3] VDD VSS u_sync_detector/_08_ gf180mcu_fd_sc_mcu9t5v0__clkinv_1
Xu_sync_detector/_21_ \_009_ int_rst_n u_sync_detector/_07_ VDD VSS u_sync_detector/_09_ gf180mcu_fd_sc_mcu9t5v0__nand3_4
Xu_sync_detector/_22_ u_sync_detector/match[0] dec_data_valid u_sync_detector/match[1] VDD VSS u_sync_detector/_10_ gf180mcu_fd_sc_mcu9t5v0__and3_2
Xu_sync_detector/_23_ u_sync_detector/match[2] u_sync_detector/_10_ VDD VSS u_sync_detector/_11_ gf180mcu_fd_sc_mcu9t5v0__and2_2
Xu_sync_detector/_24_ u_sync_detector/_08_ u_sync_detector/_09_ u_sync_detector/_11_ VDD VSS u_sync_detector/_00_ gf180mcu_fd_sc_mcu9t5v0__nor3_2
Xu_sync_detector/_25_ u_sync_detector/match[2] u_sync_detector/_10_ VDD VSS u_sync_detector/_12_ gf180mcu_fd_sc_mcu9t5v0__nor2_1
Xu_sync_detector/_26_ u_sync_detector/_09_ u_sync_detector/_11_ u_sync_detector/_12_ VDD VSS u_sync_detector/_01_ gf180mcu_fd_sc_mcu9t5v0__nor3_2
Xu_sync_detector/_27_ u_sync_detector/match[0] dec_data_valid VDD VSS u_sync_detector/_13_ gf180mcu_fd_sc_mcu9t5v0__and2_1
Xu_sync_detector/_28_ u_sync_detector/match[1] u_sync_detector/_13_ VDD VSS u_sync_detector/_14_ gf180mcu_fd_sc_mcu9t5v0__nor2_1
Xu_sync_detector/_29_ u_sync_detector/_09_ u_sync_detector/_10_ u_sync_detector/_14_ VDD VSS u_sync_detector/_02_ gf180mcu_fd_sc_mcu9t5v0__nor3_1
Xu_sync_detector/_30_ u_sync_detector/match[0] dec_data_valid VDD VSS u_sync_detector/_15_ gf180mcu_fd_sc_mcu9t5v0__nor2_1
Xu_sync_detector/_31_ u_sync_detector/_06_ u_sync_detector/_13_ u_sync_detector/_15_ u_sync_detector/_09_ VDD VSS u_sync_detector/_03_ gf180mcu_fd_sc_mcu9t5v0__aoi211_1
Xu_sync_detector/_32_ int_rst_n sync_next VDD VSS u_sync_detector/_04_ gf180mcu_fd_sc_mcu9t5v0__and2_2
Xu_sync_detector/_33_ clknet_3_3__leaf_clk u_sync_detector/_04_ u_sync_detector/sync_valid VDD VSS gf180mcu_fd_sc_mcu9t5v0__dffq_1
Xu_sync_detector/_34_ clknet_3_2__leaf_clk u_sync_detector/_03_ u_sync_detector/match[0] VDD VSS gf180mcu_fd_sc_mcu9t5v0__dffq_1
Xu_sync_detector/_35_ clknet_3_2__leaf_clk u_sync_detector/_02_ u_sync_detector/match[1] VDD VSS gf180mcu_fd_sc_mcu9t5v0__dffq_1
Xu_sync_detector/_36_ clknet_3_2__leaf_clk u_sync_detector/_01_ u_sync_detector/match[2] VDD VSS gf180mcu_fd_sc_mcu9t5v0__dffq_1
Xu_sync_detector/_37_ clknet_3_2__leaf_clk u_sync_detector/_00_ u_sync_detector/match[3] VDD VSS gf180mcu_fd_sc_mcu9t5v0__dffq_1
.ENDS
