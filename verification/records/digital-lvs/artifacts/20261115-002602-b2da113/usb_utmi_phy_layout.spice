* extracted by klt extract --deck gf180mcu

* cell usb_utmi_phy
* pin DataIn[0]
* pin DataIn[1]
* pin DataIn[2]
* pin DataIn[3]
* pin DataIn[4]
* pin DataIn[5]
* pin DataIn[6]
* pin DataIn[7]
* pin DataOut[0]
* pin DataOut[1]
* pin DataOut[2]
* pin DataOut[3]
* pin DataOut[4]
* pin DataOut[5]
* pin DataOut[6]
* pin DataOut[7]
* pin OpMode[0]
* pin OpMode[1]
* pin Reset
* pin RxError
* pin RxValid
* pin TermSelect
* pin TxReady
* pin TxValid
* pin VDD
* pin VSS
* pin clk
* pin line_state[0]
* pin line_state[1]
* pin pu_en
* pin rst_n
* pin rx_receiving
* pin rxdm
* pin rxdp
* pin txdm
* pin txdp
* pin txoe
* pin SuspendM
* pin XcvrSelect
* pin trim[0]
* pin trim[1]
* pin trim[2]
* pin trim[3]
* pin trim[4]
.SUBCKT usb_utmi_phy DataIn[0] DataIn[1] DataIn[2] DataIn[3] DataIn[4]
+ DataIn[5] DataIn[6] DataIn[7] DataOut[0] DataOut[1] DataOut[2] DataOut[3]
+ DataOut[4] DataOut[5] DataOut[6] DataOut[7] OpMode[0] OpMode[1] Reset RxError
+ RxValid TermSelect TxReady TxValid VDD VSS clk line_state[0] line_state[1]
+ pu_en rst_n rx_receiving rxdm rxdp txdm txdp txoe SuspendM XcvrSelect trim[0]
+ trim[1] trim[2] trim[3] trim[4]
* cell instance gf180mcu_fd_sc_mcu9t5v0__and2_1_0 r0 *1 0,0
Xgf180mcu_fd_sc_mcu9t5v0__and2_1_0 rx_bit_valid rx_assembly_en VDD rx_bit_valid
+ vsubs VSS \_099_ gf180mcu_fd_sc_mcu9t5v0__and2_1
* cell instance gf180mcu_fd_sc_mcu9t5v0__and2_1_1 r0 *1 0,0
Xgf180mcu_fd_sc_mcu9t5v0__and2_1_1 u_sync_detector/match[0] rx_dec_strobe VDD
+ u_sync_detector/_02_ vsubs VSS u_sync_detector/_13_
+ gf180mcu_fd_sc_mcu9t5v0__and2_1
* cell instance gf180mcu_fd_sc_mcu9t5v0__and2_1_2 r0 *1 0,0
Xgf180mcu_fd_sc_mcu9t5v0__and2_1_2 rx_stuff_err \_002_ VDD
+ gf180mcu_fd_sc_mcu9t5v0__and2_1_2__VNW vsubs VSS \_040_
+ gf180mcu_fd_sc_mcu9t5v0__and2_1
* cell instance gf180mcu_fd_sc_mcu9t5v0__and2_1_3 r0 *1 0,0
Xgf180mcu_fd_sc_mcu9t5v0__and2_1_3 \_055_ rx_dec_strobe VDD rx_dec_strobe vsubs
+ VSS \_003_ gf180mcu_fd_sc_mcu9t5v0__and2_1
* cell instance gf180mcu_fd_sc_mcu9t5v0__and2_1_4 r0 *1 0,0
Xgf180mcu_fd_sc_mcu9t5v0__and2_1_4 line_state[1] \_058_ VDD
+ gf180mcu_fd_sc_mcu9t5v0__and2_1_4__VNW vsubs VSS \_059_
+ gf180mcu_fd_sc_mcu9t5v0__and2_1
* cell instance gf180mcu_fd_sc_mcu9t5v0__and2_1_5 r0 *1 0,0
Xgf180mcu_fd_sc_mcu9t5v0__and2_1_5 u_eop_detector/_12_ u_eop_detector/_26_ VDD
+ gf180mcu_fd_sc_mcu9t5v0__and2_1_5__VNW vsubs VSS u_eop_detector/_07_
+ gf180mcu_fd_sc_mcu9t5v0__and2_1
* cell instance gf180mcu_fd_sc_mcu9t5v0__and2_1_6 r0 *1 0,0
Xgf180mcu_fd_sc_mcu9t5v0__and2_1_6 rst_n TermSelect VDD DataIn[0] vsubs VSS
+ pu_en gf180mcu_fd_sc_mcu9t5v0__and2_1
* cell instance gf180mcu_fd_sc_mcu9t5v0__and2_1_7 r0 *1 0,0
Xgf180mcu_fd_sc_mcu9t5v0__and2_1_7 \_010_ stuff_consume VDD
+ gf180mcu_fd_sc_mcu9t5v0__and2_1_7__VNW vsubs VSS stuff_bit_out
+ gf180mcu_fd_sc_mcu9t5v0__and2_1
* cell instance gf180mcu_fd_sc_mcu9t5v0__and2_1_8 r0 *1 0,0
Xgf180mcu_fd_sc_mcu9t5v0__and2_1_8 \_071_ \_097_ VDD \_097_ vsubs VSS \_137_
+ gf180mcu_fd_sc_mcu9t5v0__and2_1
* cell instance gf180mcu_fd_sc_mcu9t5v0__and2_2_0 r0 *1 0,0
Xgf180mcu_fd_sc_mcu9t5v0__and2_2_0 u_sync_detector/match[2]
+ u_sync_detector/_10_ VDD u_sync_detector/_11_ vsubs VSS u_sync_detector/_11_
+ gf180mcu_fd_sc_mcu9t5v0__and2_2
* cell instance gf180mcu_fd_sc_mcu9t5v0__and2_2_1 r0 *1 0,0
Xgf180mcu_fd_sc_mcu9t5v0__and2_2_1 \_055_ sync_next VDD VDD vsubs VSS
+ u_sync_detector/_04_ gf180mcu_fd_sc_mcu9t5v0__and2_2
* cell instance gf180mcu_fd_sc_mcu9t5v0__and2_2_2 r0 *1 0,0
Xgf180mcu_fd_sc_mcu9t5v0__and2_2_2 \_093_ \_095_ VDD VDD vsubs VSS \_098_
+ gf180mcu_fd_sc_mcu9t5v0__and2_2
* cell instance gf180mcu_fd_sc_mcu9t5v0__and2_4_0 r0 *1 0,0
Xgf180mcu_fd_sc_mcu9t5v0__and2_4_0 \_055_ rxdm VDD VDD vsubs VSS
+ u_line_state/_1_ gf180mcu_fd_sc_mcu9t5v0__and2_4
* cell instance gf180mcu_fd_sc_mcu9t5v0__and2_4_1 r0 *1 0,0
Xgf180mcu_fd_sc_mcu9t5v0__and2_4_1 tx_state[0] \_069_ VDD
+ gf180mcu_fd_sc_mcu9t5v0__and2_4_1__VNW vsubs VSS \_091_
+ gf180mcu_fd_sc_mcu9t5v0__and2_4
* cell instance gf180mcu_fd_sc_mcu9t5v0__and3_1_0 r0 *1 0,0
Xgf180mcu_fd_sc_mcu9t5v0__and3_1_0 rx_bitcnt[0] rx_bitcnt[1] \_099_ VDD \_099_
+ vsubs VSS \_100_ gf180mcu_fd_sc_mcu9t5v0__and3_1
* cell instance gf180mcu_fd_sc_mcu9t5v0__and3_1_1 r0 *1 0,0
Xgf180mcu_fd_sc_mcu9t5v0__and3_1_1 u_eop_detector/se0_count[3]
+ u_eop_detector/se0_count[2] u_eop_detector/_15_ VDD
+ gf180mcu_fd_sc_mcu9t5v0__and3_1_1__VNW vsubs VSS u_eop_detector/_24_
+ gf180mcu_fd_sc_mcu9t5v0__and3_1
* cell instance gf180mcu_fd_sc_mcu9t5v0__and3_2_0 r0 *1 0,0
Xgf180mcu_fd_sc_mcu9t5v0__and3_2_0 rx_bitcnt[2] \_002_ \_100_ VDD
+ gf180mcu_fd_sc_mcu9t5v0__and3_2_0__VNW vsubs VSS \_101_
+ gf180mcu_fd_sc_mcu9t5v0__and3_2
* cell instance gf180mcu_fd_sc_mcu9t5v0__and3_2_1 r0 *1 0,0
Xgf180mcu_fd_sc_mcu9t5v0__and3_2_1 \_002_ dec_data_bit u_destuffer/_06_ VDD
+ gf180mcu_fd_sc_mcu9t5v0__and3_2_1__VNW vsubs VSS u_destuffer/_09_
+ gf180mcu_fd_sc_mcu9t5v0__and3_2
* cell instance gf180mcu_fd_sc_mcu9t5v0__and3_2_2 r0 *1 0,0
Xgf180mcu_fd_sc_mcu9t5v0__and3_2_2 u_sync_detector/match[0] rx_dec_strobe
+ u_sync_detector/match[1] VDD gf180mcu_fd_sc_mcu9t5v0__and3_2_2__VNW vsubs VSS
+ u_sync_detector/_10_ gf180mcu_fd_sc_mcu9t5v0__and3_2
* cell instance gf180mcu_fd_sc_mcu9t5v0__and3_4_0 r0 *1 0,0
Xgf180mcu_fd_sc_mcu9t5v0__and3_4_0 u_eop_detector/se0_count[3]
+ u_eop_detector/se0_count[4] u_eop_detector/se0_count[2] VDD
+ gf180mcu_fd_sc_mcu9t5v0__and3_4_0__VNW vsubs VSS u_eop_detector/_10_
+ gf180mcu_fd_sc_mcu9t5v0__and3_4
* cell instance gf180mcu_fd_sc_mcu9t5v0__and4_1_0 r0 *1 0,0
Xgf180mcu_fd_sc_mcu9t5v0__and4_1_0 \_003_ \_002_ dec_data_bit u_destuffer/_07_
+ VDD gf180mcu_fd_sc_mcu9t5v0__and4_1_0__VNW vsubs VSS u_destuffer/_01_
+ gf180mcu_fd_sc_mcu9t5v0__and4_1
* cell instance gf180mcu_fd_sc_mcu9t5v0__and4_1_1 r0 *1 0,0
Xgf180mcu_fd_sc_mcu9t5v0__and4_1_1 \_135_ \_136_ \_137_ \_141_ VDD VSS vsubs
+ VSS \_142_ gf180mcu_fd_sc_mcu9t5v0__and4_1
* cell instance gf180mcu_fd_sc_mcu9t5v0__aoi211_1_0 r0 *1 0,0
Xgf180mcu_fd_sc_mcu9t5v0__aoi211_1_0 u_sync_detector/_06_ u_sync_detector/_13_
+ u_sync_detector/_15_ u_sync_detector/_09_ VDD rx_dec_strobe vsubs VSS
+ u_sync_detector/_03_ gf180mcu_fd_sc_mcu9t5v0__aoi211_1
* cell instance gf180mcu_fd_sc_mcu9t5v0__aoi211_1_1 r0 *1 0,0
Xgf180mcu_fd_sc_mcu9t5v0__aoi211_1_1 u_eop_detector/_14_ u_eop_detector/_18_
+ u_eop_detector/_15_ u_eop_detector/_09_ VDD VSS vsubs VSS u_eop_detector/_02_
+ gf180mcu_fd_sc_mcu9t5v0__aoi211_1
* cell instance gf180mcu_fd_sc_mcu9t5v0__aoi211_1_2 r0 *1 0,0
Xgf180mcu_fd_sc_mcu9t5v0__aoi211_1_2 \_063_ \_064_ \_091_ \_140_ VDD \_063_
+ vsubs VSS \_141_ gf180mcu_fd_sc_mcu9t5v0__aoi211_1
* cell instance gf180mcu_fd_sc_mcu9t5v0__aoi211_1_3 r0 *1 0,0
Xgf180mcu_fd_sc_mcu9t5v0__aoi211_1_3 \_158_ \_143_ \_138_ \_054_ VDD VDD vsubs
+ VSS \_048_ gf180mcu_fd_sc_mcu9t5v0__aoi211_1
* cell instance gf180mcu_fd_sc_mcu9t5v0__aoi211_1_4 r0 *1 0,0
Xgf180mcu_fd_sc_mcu9t5v0__aoi211_1_4 \_098_ \_109_ \_110_ \_054_ VDD VDD vsubs
+ VSS \_017_ gf180mcu_fd_sc_mcu9t5v0__aoi211_1
* cell instance gf180mcu_fd_sc_mcu9t5v0__aoi211_1_5 r0 *1 0,0
Xgf180mcu_fd_sc_mcu9t5v0__aoi211_1_5 byte_idx[0] \_098_ \_111_ \_054_ VDD
+ gf180mcu_fd_sc_mcu9t5v0__aoi211_1_5__VNW vsubs VSS \_018_
+ gf180mcu_fd_sc_mcu9t5v0__aoi211_1
* cell instance gf180mcu_fd_sc_mcu9t5v0__aoi211_2_0 r0 *1 0,0
Xgf180mcu_fd_sc_mcu9t5v0__aoi211_2_0 \_146_ \_102_ \_147_ \_054_ VDD \$256
+ vsubs VSS \_039_ gf180mcu_fd_sc_mcu9t5v0__aoi211_2
* cell instance gf180mcu_fd_sc_mcu9t5v0__aoi211_2_1 r0 *1 0,0
Xgf180mcu_fd_sc_mcu9t5v0__aoi211_2_1 \_105_ \_102_ \_106_ \_054_ VDD \$243
+ vsubs VSS \_016_ gf180mcu_fd_sc_mcu9t5v0__aoi211_2
* cell instance gf180mcu_fd_sc_mcu9t5v0__aoi211_2_2 r0 *1 0,0
Xgf180mcu_fd_sc_mcu9t5v0__aoi211_2_2 \_150_ \_102_ \_151_ \_054_ VDD \$258
+ vsubs VSS \_043_ gf180mcu_fd_sc_mcu9t5v0__aoi211_2
* cell instance gf180mcu_fd_sc_mcu9t5v0__aoi211_2_3 r0 *1 0,0
Xgf180mcu_fd_sc_mcu9t5v0__aoi211_2_3 \_152_ \_102_ \_153_ \_054_ VDD \$244
+ vsubs VSS \_045_ gf180mcu_fd_sc_mcu9t5v0__aoi211_2
* cell instance gf180mcu_fd_sc_mcu9t5v0__aoi211_2_4 r0 *1 0,0
Xgf180mcu_fd_sc_mcu9t5v0__aoi211_2_4 \_156_ \_102_ \_157_ \_054_ VDD \$104
+ vsubs VSS \_047_ gf180mcu_fd_sc_mcu9t5v0__aoi211_2
* cell instance gf180mcu_fd_sc_mcu9t5v0__aoi211_2_5 r0 *1 0,0
Xgf180mcu_fd_sc_mcu9t5v0__aoi211_2_5 \_162_ \_102_ \_163_ \_054_ VDD \$245
+ vsubs VSS \_051_ gf180mcu_fd_sc_mcu9t5v0__aoi211_2
* cell instance gf180mcu_fd_sc_mcu9t5v0__aoi211_2_6 r0 *1 0,0
Xgf180mcu_fd_sc_mcu9t5v0__aoi211_2_6 \_159_ \_102_ \_160_ \_054_ VDD \$166
+ vsubs VSS \_049_ gf180mcu_fd_sc_mcu9t5v0__aoi211_2
* cell instance gf180mcu_fd_sc_mcu9t5v0__aoi211_2_7 r0 *1 0,0
Xgf180mcu_fd_sc_mcu9t5v0__aoi211_2_7 \_085_ \_102_ \_149_ \_054_ VDD \$195
+ vsubs VSS \_042_ gf180mcu_fd_sc_mcu9t5v0__aoi211_2
* cell instance gf180mcu_fd_sc_mcu9t5v0__aoi211_2_8 r0 *1 0,0
Xgf180mcu_fd_sc_mcu9t5v0__aoi211_2_8 \_065_ \_138_ \_142_ \_054_ VDD \$472
+ vsubs VSS \_030_ gf180mcu_fd_sc_mcu9t5v0__aoi211_2
* cell instance gf180mcu_fd_sc_mcu9t5v0__aoi21_1_0 r0 *1 0,0
Xgf180mcu_fd_sc_mcu9t5v0__aoi21_1_0 rx_bitcnt[0] \_099_ \_127_ VDD
+ gf180mcu_fd_sc_mcu9t5v0__aoi21_1_0__VNW vsubs VSS \_026_
+ gf180mcu_fd_sc_mcu9t5v0__aoi21_1
* cell instance gf180mcu_fd_sc_mcu9t5v0__aoi21_1_1 r0 *1 0,0
Xgf180mcu_fd_sc_mcu9t5v0__aoi21_1_1 \_113_ \_115_ \_056_ VDD
+ gf180mcu_fd_sc_mcu9t5v0__aoi21_1_1__VNW vsubs VSS \_019_
+ gf180mcu_fd_sc_mcu9t5v0__aoi21_1
* cell instance gf180mcu_fd_sc_mcu9t5v0__aoi21_1_2 r0 *1 0,0
Xgf180mcu_fd_sc_mcu9t5v0__aoi21_1_2 rx_bitcnt[2] \_100_ \_148_ VDD
+ gf180mcu_fd_sc_mcu9t5v0__aoi21_1_2__VNW vsubs VSS \_041_
+ gf180mcu_fd_sc_mcu9t5v0__aoi21_1
* cell instance gf180mcu_fd_sc_mcu9t5v0__aoi21_1_3 r0 *1 0,0
Xgf180mcu_fd_sc_mcu9t5v0__aoi21_1_3 \_128_ \_129_ \_056_ VDD \_128_ vsubs VSS
+ \_027_ gf180mcu_fd_sc_mcu9t5v0__aoi21_1
* cell instance gf180mcu_fd_sc_mcu9t5v0__aoi21_1_4 r0 *1 0,0
Xgf180mcu_fd_sc_mcu9t5v0__aoi21_1_4 rx_bitcnt[0] \_099_ rx_bitcnt[1] VDD
+ gf180mcu_fd_sc_mcu9t5v0__aoi21_1_4__VNW vsubs VSS \_126_
+ gf180mcu_fd_sc_mcu9t5v0__aoi21_1
* cell instance gf180mcu_fd_sc_mcu9t5v0__aoi21_1_5 r0 *1 0,0
Xgf180mcu_fd_sc_mcu9t5v0__aoi21_1_5 u_destuffer/ones_run[1] u_destuffer/_12_
+ u_destuffer/ones_run[2] VDD gf180mcu_fd_sc_mcu9t5v0__aoi21_1_5__VNW vsubs VSS
+ u_destuffer/_14_ gf180mcu_fd_sc_mcu9t5v0__aoi21_1
* cell instance gf180mcu_fd_sc_mcu9t5v0__aoi21_1_6 r0 *1 0,0
Xgf180mcu_fd_sc_mcu9t5v0__aoi21_1_6 \_116_ \_117_ \_056_ VDD \_116_ vsubs VSS
+ \_020_ gf180mcu_fd_sc_mcu9t5v0__aoi21_1
* cell instance gf180mcu_fd_sc_mcu9t5v0__aoi21_1_7 r0 *1 0,0
Xgf180mcu_fd_sc_mcu9t5v0__aoi21_1_7 \_124_ \_125_ \_056_ VDD \_125_ vsubs VSS
+ \_024_ gf180mcu_fd_sc_mcu9t5v0__aoi21_1
* cell instance gf180mcu_fd_sc_mcu9t5v0__aoi21_1_8 r0 *1 0,0
Xgf180mcu_fd_sc_mcu9t5v0__aoi21_1_8 \_003_ u_destuffer/_09_
+ u_destuffer/ones_run[0] VDD gf180mcu_fd_sc_mcu9t5v0__aoi21_1_8__VNW vsubs VSS
+ u_destuffer/_15_ gf180mcu_fd_sc_mcu9t5v0__aoi21_1
* cell instance gf180mcu_fd_sc_mcu9t5v0__aoi21_1_9 r0 *1 0,0
Xgf180mcu_fd_sc_mcu9t5v0__aoi21_1_9 \_120_ \_121_ \_056_ VDD \_120_ vsubs VSS
+ \_022_ gf180mcu_fd_sc_mcu9t5v0__aoi21_1
* cell instance gf180mcu_fd_sc_mcu9t5v0__aoi21_1_10 r0 *1 0,0
Xgf180mcu_fd_sc_mcu9t5v0__aoi21_1_10 \_154_ \_155_ \_056_ VDD \_154_ vsubs VSS
+ \_046_ gf180mcu_fd_sc_mcu9t5v0__aoi21_1
* cell instance gf180mcu_fd_sc_mcu9t5v0__aoi21_1_11 r0 *1 0,0
Xgf180mcu_fd_sc_mcu9t5v0__aoi21_1_11 \_122_ \_123_ \_056_ VDD \_122_ vsubs VSS
+ \_023_ gf180mcu_fd_sc_mcu9t5v0__aoi21_1
* cell instance gf180mcu_fd_sc_mcu9t5v0__aoi21_1_12 r0 *1 0,0
Xgf180mcu_fd_sc_mcu9t5v0__aoi21_1_12 u_eop_detector/_22_ u_eop_detector/_23_
+ u_eop_detector/_09_ VDD gf180mcu_fd_sc_mcu9t5v0__aoi21_1_12__VNW vsubs VSS
+ u_eop_detector/_04_ gf180mcu_fd_sc_mcu9t5v0__aoi21_1
* cell instance gf180mcu_fd_sc_mcu9t5v0__aoi21_1_13 r0 *1 0,0
Xgf180mcu_fd_sc_mcu9t5v0__aoi21_1_13 u_eop_detector/se0_count[2]
+ u_eop_detector/_15_ u_eop_detector/se0_count[3] VDD
+ gf180mcu_fd_sc_mcu9t5v0__aoi21_1_13__VNW vsubs VSS u_eop_detector/_25_
+ gf180mcu_fd_sc_mcu9t5v0__aoi21_1
* cell instance gf180mcu_fd_sc_mcu9t5v0__aoi21_1_14 r0 *1 0,0
Xgf180mcu_fd_sc_mcu9t5v0__aoi21_1_14 u_eop_detector/_10_ u_eop_detector/_12_
+ bus_reset VDD u_eop_detector/_10_ vsubs VSS u_eop_detector/_13_
+ gf180mcu_fd_sc_mcu9t5v0__aoi21_1
* cell instance gf180mcu_fd_sc_mcu9t5v0__aoi21_1_15 r0 *1 0,0
Xgf180mcu_fd_sc_mcu9t5v0__aoi21_1_15 \_063_ \_064_ txdm VDD VSS vsubs VSS txdp
+ gf180mcu_fd_sc_mcu9t5v0__aoi21_1
* cell instance gf180mcu_fd_sc_mcu9t5v0__aoi21_1_16 r0 *1 0,0
Xgf180mcu_fd_sc_mcu9t5v0__aoi21_1_16 u_eop_detector/se0_count[1]
+ u_eop_detector/_10_ u_eop_detector/_18_ VDD u_eop_detector/se0_count[1] vsubs
+ VSS u_eop_detector/_19_ gf180mcu_fd_sc_mcu9t5v0__aoi21_1
* cell instance gf180mcu_fd_sc_mcu9t5v0__aoi21_1_17 r0 *1 0,0
Xgf180mcu_fd_sc_mcu9t5v0__aoi21_1_17 u_eop_detector/_17_ u_eop_detector/_20_
+ u_eop_detector/se0_count[0] VDD VSS vsubs VSS u_eop_detector/_21_
+ gf180mcu_fd_sc_mcu9t5v0__aoi21_1
* cell instance gf180mcu_fd_sc_mcu9t5v0__aoi21_1_18 r0 *1 0,0
Xgf180mcu_fd_sc_mcu9t5v0__aoi21_1_18 \_075_ \_104_ \_054_ VDD
+ gf180mcu_fd_sc_mcu9t5v0__aoi21_1_18__VNW vsubs VSS \_014_
+ gf180mcu_fd_sc_mcu9t5v0__aoi21_1
* cell instance gf180mcu_fd_sc_mcu9t5v0__aoi21_1_19 r0 *1 0,0
Xgf180mcu_fd_sc_mcu9t5v0__aoi21_1_19 byte_reg[4] byte_idx[2] \_082_ VDD \_077_
+ vsubs VSS \_083_ gf180mcu_fd_sc_mcu9t5v0__aoi21_1
* cell instance gf180mcu_fd_sc_mcu9t5v0__aoi21_1_20 r0 *1 0,0
Xgf180mcu_fd_sc_mcu9t5v0__aoi21_1_20 \_075_ \_134_ \_054_ VDD
+ gf180mcu_fd_sc_mcu9t5v0__aoi21_1_20__VNW vsubs VSS \_029_
+ gf180mcu_fd_sc_mcu9t5v0__aoi21_1
* cell instance gf180mcu_fd_sc_mcu9t5v0__aoi21_1_21 r0 *1 0,0
Xgf180mcu_fd_sc_mcu9t5v0__aoi21_1_21 byte_reg[1] \_080_ byte_idx[1] VDD VSS
+ vsubs VSS \_086_ gf180mcu_fd_sc_mcu9t5v0__aoi21_1
* cell instance gf180mcu_fd_sc_mcu9t5v0__aoi21_1_22 r0 *1 0,0
Xgf180mcu_fd_sc_mcu9t5v0__aoi21_1_22 sync_idx[0] \_091_ sync_idx[1] VDD
+ gf180mcu_fd_sc_mcu9t5v0__aoi21_1_22__VNW vsubs VSS \_130_
+ gf180mcu_fd_sc_mcu9t5v0__aoi21_1
* cell instance gf180mcu_fd_sc_mcu9t5v0__aoi21_1_23 r0 *1 0,0
Xgf180mcu_fd_sc_mcu9t5v0__aoi21_1_23 \_073_ \_091_ \_092_ VDD \_073_ vsubs VSS
+ \_135_ gf180mcu_fd_sc_mcu9t5v0__aoi21_1
* cell instance gf180mcu_fd_sc_mcu9t5v0__aoi21_1_24 r0 *1 0,0
Xgf180mcu_fd_sc_mcu9t5v0__aoi21_1_24 \_107_ \_093_ byte_idx[0] VDD
+ clknet_3_5__leaf_clk vsubs VSS \_111_ gf180mcu_fd_sc_mcu9t5v0__aoi21_1
* cell instance gf180mcu_fd_sc_mcu9t5v0__aoi21_1_25 r0 *1 0,0
Xgf180mcu_fd_sc_mcu9t5v0__aoi21_1_25 \_093_ \_095_ byte_idx[1] VDD
+ gf180mcu_fd_sc_mcu9t5v0__aoi21_1_25__VNW vsubs VSS \_110_
+ gf180mcu_fd_sc_mcu9t5v0__aoi21_1
* cell instance gf180mcu_fd_sc_mcu9t5v0__aoi21_2_0 r0 *1 0,0
Xgf180mcu_fd_sc_mcu9t5v0__aoi21_2_0 u_destuffer/_08_ \_002_ u_destuffer/_09_
+ VDD gf180mcu_fd_sc_mcu9t5v0__aoi21_2_0__VNW vsubs VSS u_destuffer/_10_
+ gf180mcu_fd_sc_mcu9t5v0__aoi21_2
* cell instance gf180mcu_fd_sc_mcu9t5v0__aoi21_2_1 r0 *1 0,0
Xgf180mcu_fd_sc_mcu9t5v0__aoi21_2_1 u_stuffer/_03_ stuff_consume \_000_ VDD
+ u_stuffer/_04_ vsubs VSS u_stuffer/_06_ gf180mcu_fd_sc_mcu9t5v0__aoi21_2
* cell instance gf180mcu_fd_sc_mcu9t5v0__aoi21_2_2 r0 *1 0,0
Xgf180mcu_fd_sc_mcu9t5v0__aoi21_2_2 \_005_ u_stuffer/_09_ u_stuffer/_11_ VDD
+ VDD vsubs VSS u_stuffer/_01_ gf180mcu_fd_sc_mcu9t5v0__aoi21_2
* cell instance gf180mcu_fd_sc_mcu9t5v0__aoi21_2_3 r0 *1 0,0
Xgf180mcu_fd_sc_mcu9t5v0__aoi21_2_3 \_005_ u_stuffer/_09_ u_stuffer/_13_ VDD
+ VDD vsubs VSS u_stuffer/_02_ gf180mcu_fd_sc_mcu9t5v0__aoi21_2
* cell instance gf180mcu_fd_sc_mcu9t5v0__aoi21_4_0 r0 *1 0,0
Xgf180mcu_fd_sc_mcu9t5v0__aoi21_4_0 \_002_ u_destuffer/_07_ u_destuffer/_08_
+ VDD \$615 vsubs VSS u_destuffer/_00_ gf180mcu_fd_sc_mcu9t5v0__aoi21_4
* cell instance gf180mcu_fd_sc_mcu9t5v0__aoi21_4_1 r0 *1 0,0
Xgf180mcu_fd_sc_mcu9t5v0__aoi21_4_1 u_destuffer/_08_ \_002_ u_destuffer/_11_
+ VDD \$686 vsubs VSS u_destuffer/_12_ gf180mcu_fd_sc_mcu9t5v0__aoi21_4
* cell instance gf180mcu_fd_sc_mcu9t5v0__aoi221_1_0 r0 *1 0,0
Xgf180mcu_fd_sc_mcu9t5v0__aoi221_1_0 byte_idx[1] \_079_ \_081_ \_083_ \_088_
+ VDD gf180mcu_fd_sc_mcu9t5v0__aoi221_1_0__VNW vsubs VSS \_010_
+ gf180mcu_fd_sc_mcu9t5v0__aoi221_1
* cell instance gf180mcu_fd_sc_mcu9t5v0__aoi221_2_0 r0 *1 0,0
Xgf180mcu_fd_sc_mcu9t5v0__aoi221_2_0 \_070_ \_067_ \_073_ \_091_ \_092_ VDD
+ gf180mcu_fd_sc_mcu9t5v0__aoi221_2_0__VNW vsubs VSS \_093_
+ gf180mcu_fd_sc_mcu9t5v0__aoi221_2
* cell instance gf180mcu_fd_sc_mcu9t5v0__aoi221_2_1 r0 *1 0,0
Xgf180mcu_fd_sc_mcu9t5v0__aoi221_2_1 \_080_ \_096_ \_097_ \_098_ \_054_ VDD VDD
+ vsubs VSS \_012_ gf180mcu_fd_sc_mcu9t5v0__aoi221_2
* cell instance gf180mcu_fd_sc_mcu9t5v0__buf_4_0 r0 *1 0,0
Xgf180mcu_fd_sc_mcu9t5v0__buf_4_0 clknet_0_clk VDD clknet_3_0__leaf_clk vsubs
+ VSS clknet_3_0__leaf_clk gf180mcu_fd_sc_mcu9t5v0__buf_4
* cell instance gf180mcu_fd_sc_mcu9t5v0__buf_4_1 r0 *1 0,0
Xgf180mcu_fd_sc_mcu9t5v0__buf_4_1 clknet_0_clk VDD u_sync_detector/_03_ vsubs
+ VSS clknet_3_2__leaf_clk gf180mcu_fd_sc_mcu9t5v0__buf_4
* cell instance gf180mcu_fd_sc_mcu9t5v0__buf_4_2 r0 *1 0,0
Xgf180mcu_fd_sc_mcu9t5v0__buf_4_2 clknet_0_clk VDD
+ gf180mcu_fd_sc_mcu9t5v0__buf_4_2__VNW vsubs VSS clknet_3_1__leaf_clk
+ gf180mcu_fd_sc_mcu9t5v0__buf_4
* cell instance gf180mcu_fd_sc_mcu9t5v0__buf_4_3 r0 *1 0,0
Xgf180mcu_fd_sc_mcu9t5v0__buf_4_3 clknet_0_clk VDD VSS vsubs VSS
+ clknet_3_3__leaf_clk gf180mcu_fd_sc_mcu9t5v0__buf_4
* cell instance gf180mcu_fd_sc_mcu9t5v0__buf_4_4 r0 *1 0,0
Xgf180mcu_fd_sc_mcu9t5v0__buf_4_4 clk VDD gf180mcu_fd_sc_mcu9t5v0__buf_4_4__VNW
+ vsubs VSS clknet_0_clk gf180mcu_fd_sc_mcu9t5v0__buf_4
* cell instance gf180mcu_fd_sc_mcu9t5v0__buf_4_5 r0 *1 0,0
Xgf180mcu_fd_sc_mcu9t5v0__buf_4_5 clknet_0_clk VDD
+ gf180mcu_fd_sc_mcu9t5v0__buf_4_5__VNW vsubs VSS clknet_3_6__leaf_clk
+ gf180mcu_fd_sc_mcu9t5v0__buf_4
* cell instance gf180mcu_fd_sc_mcu9t5v0__buf_4_6 r0 *1 0,0
Xgf180mcu_fd_sc_mcu9t5v0__buf_4_6 clknet_0_clk VDD TxValid vsubs VSS
+ clknet_3_4__leaf_clk gf180mcu_fd_sc_mcu9t5v0__buf_4
* cell instance gf180mcu_fd_sc_mcu9t5v0__buf_4_7 r0 *1 0,0
Xgf180mcu_fd_sc_mcu9t5v0__buf_4_7 clknet_0_clk VDD
+ gf180mcu_fd_sc_mcu9t5v0__buf_4_7__VNW vsubs VSS clknet_3_5__leaf_clk
+ gf180mcu_fd_sc_mcu9t5v0__buf_4
* cell instance gf180mcu_fd_sc_mcu9t5v0__buf_4_8 r0 *1 0,0
Xgf180mcu_fd_sc_mcu9t5v0__buf_4_8 clknet_0_clk VDD
+ gf180mcu_fd_sc_mcu9t5v0__buf_4_8__VNW vsubs VSS clknet_3_7__leaf_clk
+ gf180mcu_fd_sc_mcu9t5v0__buf_4
* cell instance gf180mcu_fd_sc_mcu9t5v0__clkinv_1_0 r0 *1 0,0
Xgf180mcu_fd_sc_mcu9t5v0__clkinv_1_0 \_056_ VDD \_031_ vsubs VSS \_031_
+ gf180mcu_fd_sc_mcu9t5v0__clkinv_1
* cell instance gf180mcu_fd_sc_mcu9t5v0__clkinv_1_1 r0 *1 0,0
Xgf180mcu_fd_sc_mcu9t5v0__clkinv_1_1 u_sync_detector/match[3] VDD
+ gf180mcu_fd_sc_mcu9t5v0__clkinv_1_1__VNW vsubs VSS u_sync_detector/_08_
+ gf180mcu_fd_sc_mcu9t5v0__clkinv_1
* cell instance gf180mcu_fd_sc_mcu9t5v0__clkinv_1_2 r0 *1 0,0
Xgf180mcu_fd_sc_mcu9t5v0__clkinv_1_2 \_004_ VDD VSS vsubs VSS
+ u_sync_detector/_05_ gf180mcu_fd_sc_mcu9t5v0__clkinv_1
* cell instance gf180mcu_fd_sc_mcu9t5v0__clkinv_1_3 r0 *1 0,0
Xgf180mcu_fd_sc_mcu9t5v0__clkinv_1_3 rx_receiving VDD \_004_ vsubs VSS \_004_
+ gf180mcu_fd_sc_mcu9t5v0__clkinv_1
* cell instance gf180mcu_fd_sc_mcu9t5v0__clkinv_1_4 r0 *1 0,0
Xgf180mcu_fd_sc_mcu9t5v0__clkinv_1_4 Reset VDD TxReady vsubs VSS \_053_
+ gf180mcu_fd_sc_mcu9t5v0__clkinv_1
* cell instance gf180mcu_fd_sc_mcu9t5v0__clkinv_1_5 r0 *1 0,0
Xgf180mcu_fd_sc_mcu9t5v0__clkinv_1_5 u_decoder/_04_ VDD
+ gf180mcu_fd_sc_mcu9t5v0__clkinv_1_5__VNW vsubs VSS u_decoder/_00_
+ gf180mcu_fd_sc_mcu9t5v0__clkinv_1
* cell instance gf180mcu_fd_sc_mcu9t5v0__clkinv_1_6 r0 *1 0,0
Xgf180mcu_fd_sc_mcu9t5v0__clkinv_1_6 \_052_ VDD txoe vsubs VSS txoe
+ gf180mcu_fd_sc_mcu9t5v0__clkinv_1
* cell instance gf180mcu_fd_sc_mcu9t5v0__clkinv_1_7 r0 *1 0,0
Xgf180mcu_fd_sc_mcu9t5v0__clkinv_1_7 byte_reg[7] VDD
+ gf180mcu_fd_sc_mcu9t5v0__clkinv_1_7__VNW vsubs VSS \_105_
+ gf180mcu_fd_sc_mcu9t5v0__clkinv_1
* cell instance gf180mcu_fd_sc_mcu9t5v0__clkinv_1_8 r0 *1 0,0
Xgf180mcu_fd_sc_mcu9t5v0__clkinv_1_8 byte_reg[6] VDD \_146_ vsubs VSS \_146_
+ gf180mcu_fd_sc_mcu9t5v0__clkinv_1
* cell instance gf180mcu_fd_sc_mcu9t5v0__clkinv_1_9 r0 *1 0,0
Xgf180mcu_fd_sc_mcu9t5v0__clkinv_1_9 u_eop_detector/se0_count[4] VDD
+ u_eop_detector/_22_ vsubs VSS u_eop_detector/_22_
+ gf180mcu_fd_sc_mcu9t5v0__clkinv_1
* cell instance gf180mcu_fd_sc_mcu9t5v0__clkinv_1_10 r0 *1 0,0
Xgf180mcu_fd_sc_mcu9t5v0__clkinv_1_10 line_state[0] VDD clknet_0_clk vsubs VSS
+ \_058_ gf180mcu_fd_sc_mcu9t5v0__clkinv_1
* cell instance gf180mcu_fd_sc_mcu9t5v0__clkinv_1_11 r0 *1 0,0
Xgf180mcu_fd_sc_mcu9t5v0__clkinv_1_11 dec_data_strobe VDD \_057_ vsubs VSS
+ \_057_ gf180mcu_fd_sc_mcu9t5v0__clkinv_1
* cell instance gf180mcu_fd_sc_mcu9t5v0__clkinv_1_12 r0 *1 0,0
Xgf180mcu_fd_sc_mcu9t5v0__clkinv_1_12 byte_reg[4] VDD
+ gf180mcu_fd_sc_mcu9t5v0__clkinv_1_12__VNW vsubs VSS \_150_
+ gf180mcu_fd_sc_mcu9t5v0__clkinv_1
* cell instance gf180mcu_fd_sc_mcu9t5v0__clkinv_1_13 r0 *1 0,0
Xgf180mcu_fd_sc_mcu9t5v0__clkinv_1_13 OpMode[1] VDD VSS vsubs VSS \_076_
+ gf180mcu_fd_sc_mcu9t5v0__clkinv_1
* cell instance gf180mcu_fd_sc_mcu9t5v0__clkinv_1_14 r0 *1 0,0
Xgf180mcu_fd_sc_mcu9t5v0__clkinv_1_14 byte_reg[3] VDD byte_reg[7] vsubs VSS
+ \_152_ gf180mcu_fd_sc_mcu9t5v0__clkinv_1
* cell instance gf180mcu_fd_sc_mcu9t5v0__clkinv_1_15 r0 *1 0,0
Xgf180mcu_fd_sc_mcu9t5v0__clkinv_1_15 byte_reg[2] VDD DataIn[0] vsubs VSS
+ \_156_ gf180mcu_fd_sc_mcu9t5v0__clkinv_1
* cell instance gf180mcu_fd_sc_mcu9t5v0__clkinv_1_16 r0 *1 0,0
Xgf180mcu_fd_sc_mcu9t5v0__clkinv_1_16 raw_mode VDD raw_mode vsubs VSS
+ u_stuffer/_07_ gf180mcu_fd_sc_mcu9t5v0__clkinv_1
* cell instance gf180mcu_fd_sc_mcu9t5v0__clkinv_1_17 r0 *1 0,0
Xgf180mcu_fd_sc_mcu9t5v0__clkinv_1_17 \_078_ VDD \_077_ vsubs VSS \_079_
+ gf180mcu_fd_sc_mcu9t5v0__clkinv_1
* cell instance gf180mcu_fd_sc_mcu9t5v0__clkinv_1_18 r0 *1 0,0
Xgf180mcu_fd_sc_mcu9t5v0__clkinv_1_18 u_eop_detector/se0_count[0] VDD
+ u_eop_detector/_11_ vsubs VSS u_eop_detector/_11_
+ gf180mcu_fd_sc_mcu9t5v0__clkinv_1
* cell instance gf180mcu_fd_sc_mcu9t5v0__clkinv_1_19 r0 *1 0,0
Xgf180mcu_fd_sc_mcu9t5v0__clkinv_1_19 byte_reg[0] VDD \_162_ vsubs VSS \_162_
+ gf180mcu_fd_sc_mcu9t5v0__clkinv_1
* cell instance gf180mcu_fd_sc_mcu9t5v0__clkinv_1_20 r0 *1 0,0
Xgf180mcu_fd_sc_mcu9t5v0__clkinv_1_20 u_eop_detector/se0_count[5] VDD
+ u_eop_detector/_12_ vsubs VSS u_eop_detector/_17_
+ gf180mcu_fd_sc_mcu9t5v0__clkinv_1
* cell instance gf180mcu_fd_sc_mcu9t5v0__clkinv_1_21 r0 *1 0,0
Xgf180mcu_fd_sc_mcu9t5v0__clkinv_1_21 TxValid VDD
+ gf180mcu_fd_sc_mcu9t5v0__clkinv_1_21__VNW vsubs VSS \_070_
+ gf180mcu_fd_sc_mcu9t5v0__clkinv_1
* cell instance gf180mcu_fd_sc_mcu9t5v0__clkinv_1_22 r0 *1 0,0
Xgf180mcu_fd_sc_mcu9t5v0__clkinv_1_22 stuff_pending_after VDD
+ gf180mcu_fd_sc_mcu9t5v0__clkinv_1_22__VNW vsubs VSS \_139_
+ gf180mcu_fd_sc_mcu9t5v0__clkinv_1
* cell instance gf180mcu_fd_sc_mcu9t5v0__clkinv_1_23 r0 *1 0,0
Xgf180mcu_fd_sc_mcu9t5v0__clkinv_1_23 byte_reg[1] VDD clknet_3_5__leaf_clk
+ vsubs VSS \_159_ gf180mcu_fd_sc_mcu9t5v0__clkinv_1
* cell instance gf180mcu_fd_sc_mcu9t5v0__clkinv_1_24 r0 *1 0,0
Xgf180mcu_fd_sc_mcu9t5v0__clkinv_1_24 byte_reg[5] VDD
+ gf180mcu_fd_sc_mcu9t5v0__clkinv_1_24__VNW vsubs VSS \_085_
+ gf180mcu_fd_sc_mcu9t5v0__clkinv_1
* cell instance gf180mcu_fd_sc_mcu9t5v0__clkinv_1_25 r0 *1 0,0
Xgf180mcu_fd_sc_mcu9t5v0__clkinv_1_25 tx_state[2] VDD VSS vsubs VSS \_060_
+ gf180mcu_fd_sc_mcu9t5v0__clkinv_1
* cell instance gf180mcu_fd_sc_mcu9t5v0__clkinv_1_26 r0 *1 0,0
Xgf180mcu_fd_sc_mcu9t5v0__clkinv_1_26 sync_idx[2] VDD \_161_ vsubs VSS \_161_
+ gf180mcu_fd_sc_mcu9t5v0__clkinv_1
* cell instance gf180mcu_fd_sc_mcu9t5v0__clkinv_1_27 r0 *1 0,0
Xgf180mcu_fd_sc_mcu9t5v0__clkinv_1_27 byte_idx[2] VDD VDD vsubs VSS \_080_
+ gf180mcu_fd_sc_mcu9t5v0__clkinv_1
* cell instance gf180mcu_fd_sc_mcu9t5v0__clkinv_1_28 r0 *1 0,0
Xgf180mcu_fd_sc_mcu9t5v0__clkinv_1_28 \_064_ VDD VSS vsubs VSS \_094_
+ gf180mcu_fd_sc_mcu9t5v0__clkinv_1
* cell instance gf180mcu_fd_sc_mcu9t5v0__clkinv_2_0 r0 *1 0,0
Xgf180mcu_fd_sc_mcu9t5v0__clkinv_2_0 \_056_ VDD VSS vsubs VSS \_002_
+ gf180mcu_fd_sc_mcu9t5v0__clkinv_2
* cell instance gf180mcu_fd_sc_mcu9t5v0__clkinv_2_1 r0 *1 0,0
Xgf180mcu_fd_sc_mcu9t5v0__clkinv_2_1 tx_state[0] VDD byte_idx[2] vsubs VSS
+ \_084_ gf180mcu_fd_sc_mcu9t5v0__clkinv_2
* cell instance gf180mcu_fd_sc_mcu9t5v0__clkinv_8_0 r0 *1 0,0
Xgf180mcu_fd_sc_mcu9t5v0__clkinv_8_0 clknet_3_5__leaf_clk VDD \_000_ vsubs VSS
+ \$371 gf180mcu_fd_sc_mcu9t5v0__clkinv_8
* cell instance gf180mcu_fd_sc_mcu9t5v0__clkinv_8_1 r0 *1 0,0
Xgf180mcu_fd_sc_mcu9t5v0__clkinv_8_1 clknet_3_7__leaf_clk VDD
+ gf180mcu_fd_sc_mcu9t5v0__clkinv_8_1__VNW vsubs VSS \$901
+ gf180mcu_fd_sc_mcu9t5v0__clkinv_8
* cell instance gf180mcu_fd_sc_mcu9t5v0__dffq_1_0 r0 *1 0,0
Xgf180mcu_fd_sc_mcu9t5v0__dffq_1_0 clknet_3_0__leaf_clk \_019_ rx_shift[4] VDD
+ gf180mcu_fd_sc_mcu9t5v0__dffq_1_0__VNW vsubs VSS
+ gf180mcu_fd_sc_mcu9t5v0__dffq_1
* cell instance gf180mcu_fd_sc_mcu9t5v0__dffq_1_1 r0 *1 0,0
Xgf180mcu_fd_sc_mcu9t5v0__dffq_1_1 clknet_3_0__leaf_clk \_027_ rx_shift[5] VDD
+ gf180mcu_fd_sc_mcu9t5v0__dffq_1_1__VNW vsubs VSS
+ gf180mcu_fd_sc_mcu9t5v0__dffq_1
* cell instance gf180mcu_fd_sc_mcu9t5v0__dffq_1_2 r0 *1 0,0
Xgf180mcu_fd_sc_mcu9t5v0__dffq_1_2 clknet_3_0__leaf_clk \_026_ rx_bitcnt[0] VDD
+ gf180mcu_fd_sc_mcu9t5v0__dffq_1_2__VNW vsubs VSS
+ gf180mcu_fd_sc_mcu9t5v0__dffq_1
* cell instance gf180mcu_fd_sc_mcu9t5v0__dffq_1_3 r0 *1 0,0
Xgf180mcu_fd_sc_mcu9t5v0__dffq_1_3 clknet_3_2__leaf_clk \_041_ rx_bitcnt[2] VDD
+ gf180mcu_fd_sc_mcu9t5v0__dffq_1_3__VNW vsubs VSS
+ gf180mcu_fd_sc_mcu9t5v0__dffq_1
* cell instance gf180mcu_fd_sc_mcu9t5v0__dffq_1_4 r0 *1 0,0
Xgf180mcu_fd_sc_mcu9t5v0__dffq_1_4 clknet_3_0__leaf_clk \_035_ DataIn[4] VDD
+ gf180mcu_fd_sc_mcu9t5v0__dffq_1_4__VNW vsubs VSS
+ gf180mcu_fd_sc_mcu9t5v0__dffq_1
* cell instance gf180mcu_fd_sc_mcu9t5v0__dffq_1_5 r0 *1 0,0
Xgf180mcu_fd_sc_mcu9t5v0__dffq_1_5 clknet_3_0__leaf_clk \_025_ rx_bitcnt[1] VDD
+ VSS vsubs VSS gf180mcu_fd_sc_mcu9t5v0__dffq_1
* cell instance gf180mcu_fd_sc_mcu9t5v0__dffq_1_6 r0 *1 0,0
Xgf180mcu_fd_sc_mcu9t5v0__dffq_1_6 clknet_3_0__leaf_clk \_036_ DataIn[3] VDD
+ gf180mcu_fd_sc_mcu9t5v0__dffq_1_6__VNW vsubs VSS
+ gf180mcu_fd_sc_mcu9t5v0__dffq_1
* cell instance gf180mcu_fd_sc_mcu9t5v0__dffq_1_7 r0 *1 0,0
Xgf180mcu_fd_sc_mcu9t5v0__dffq_1_7 clknet_3_0__leaf_clk \_020_ rx_shift[3] VDD
+ VDD vsubs VSS gf180mcu_fd_sc_mcu9t5v0__dffq_1
* cell instance gf180mcu_fd_sc_mcu9t5v0__dffq_1_8 r0 *1 0,0
Xgf180mcu_fd_sc_mcu9t5v0__dffq_1_8 clknet_3_0__leaf_clk \_024_ rx_shift[6] VDD
+ VDD vsubs VSS gf180mcu_fd_sc_mcu9t5v0__dffq_1
* cell instance gf180mcu_fd_sc_mcu9t5v0__dffq_1_9 r0 *1 0,0
Xgf180mcu_fd_sc_mcu9t5v0__dffq_1_9 clknet_3_0__leaf_clk \_031_ rx_assembly_en
+ VDD VDD vsubs VSS gf180mcu_fd_sc_mcu9t5v0__dffq_1
* cell instance gf180mcu_fd_sc_mcu9t5v0__dffq_1_10 r0 *1 0,0
Xgf180mcu_fd_sc_mcu9t5v0__dffq_1_10 clknet_3_0__leaf_clk \_038_ DataIn[2] VDD
+ gf180mcu_fd_sc_mcu9t5v0__dffq_1_10__VNW vsubs VSS
+ gf180mcu_fd_sc_mcu9t5v0__dffq_1
* cell instance gf180mcu_fd_sc_mcu9t5v0__dffq_1_11 r0 *1 0,0
Xgf180mcu_fd_sc_mcu9t5v0__dffq_1_11 clknet_3_2__leaf_clk u_sync_detector/_03_
+ u_sync_detector/match[0] VDD gf180mcu_fd_sc_mcu9t5v0__dffq_1_11__VNW vsubs
+ VSS gf180mcu_fd_sc_mcu9t5v0__dffq_1
* cell instance gf180mcu_fd_sc_mcu9t5v0__dffq_1_12 r0 *1 0,0
Xgf180mcu_fd_sc_mcu9t5v0__dffq_1_12 clknet_3_2__leaf_clk u_sync_detector/_02_
+ u_sync_detector/match[1] VDD gf180mcu_fd_sc_mcu9t5v0__dffq_1_12__VNW vsubs
+ VSS gf180mcu_fd_sc_mcu9t5v0__dffq_1
* cell instance gf180mcu_fd_sc_mcu9t5v0__dffq_1_13 r0 *1 0,0
Xgf180mcu_fd_sc_mcu9t5v0__dffq_1_13 clknet_3_0__leaf_clk \_034_ DataIn[5] VDD
+ gf180mcu_fd_sc_mcu9t5v0__dffq_1_13__VNW vsubs VSS
+ gf180mcu_fd_sc_mcu9t5v0__dffq_1
* cell instance gf180mcu_fd_sc_mcu9t5v0__dffq_1_14 r0 *1 0,0
Xgf180mcu_fd_sc_mcu9t5v0__dffq_1_14 clknet_3_0__leaf_clk \_022_ rx_shift[2] VDD
+ gf180mcu_fd_sc_mcu9t5v0__dffq_1_14__VNW vsubs VSS
+ gf180mcu_fd_sc_mcu9t5v0__dffq_1
* cell instance gf180mcu_fd_sc_mcu9t5v0__dffq_1_15 r0 *1 0,0
Xgf180mcu_fd_sc_mcu9t5v0__dffq_1_15 clknet_3_2__leaf_clk u_sync_detector/_01_
+ u_sync_detector/match[2] VDD u_sync_detector/match[2] vsubs VSS
+ gf180mcu_fd_sc_mcu9t5v0__dffq_1
* cell instance gf180mcu_fd_sc_mcu9t5v0__dffq_1_16 r0 *1 0,0
Xgf180mcu_fd_sc_mcu9t5v0__dffq_1_16 clknet_3_0__leaf_clk \_046_ rx_shift[7] VDD
+ VSS vsubs VSS gf180mcu_fd_sc_mcu9t5v0__dffq_1
* cell instance gf180mcu_fd_sc_mcu9t5v0__dffq_1_17 r0 *1 0,0
Xgf180mcu_fd_sc_mcu9t5v0__dffq_1_17 clknet_3_1__leaf_clk \_023_ rx_shift[1] VDD
+ gf180mcu_fd_sc_mcu9t5v0__dffq_1_17__VNW vsubs VSS
+ gf180mcu_fd_sc_mcu9t5v0__dffq_1
* cell instance gf180mcu_fd_sc_mcu9t5v0__dffq_1_18 r0 *1 0,0
Xgf180mcu_fd_sc_mcu9t5v0__dffq_1_18 clknet_3_1__leaf_clk \_013_ DataIn[1] VDD
+ gf180mcu_fd_sc_mcu9t5v0__dffq_1_18__VNW vsubs VSS
+ gf180mcu_fd_sc_mcu9t5v0__dffq_1
* cell instance gf180mcu_fd_sc_mcu9t5v0__dffq_1_19 r0 *1 0,0
Xgf180mcu_fd_sc_mcu9t5v0__dffq_1_19 clknet_3_1__leaf_clk \_015_ DataIn[0] VDD
+ gf180mcu_fd_sc_mcu9t5v0__dffq_1_19__VNW vsubs VSS
+ gf180mcu_fd_sc_mcu9t5v0__dffq_1
* cell instance gf180mcu_fd_sc_mcu9t5v0__dffq_1_20 r0 *1 0,0
Xgf180mcu_fd_sc_mcu9t5v0__dffq_1_20 clknet_3_1__leaf_clk \_037_ DataIn[7] VDD
+ gf180mcu_fd_sc_mcu9t5v0__dffq_1_20__VNW vsubs VSS
+ gf180mcu_fd_sc_mcu9t5v0__dffq_1
* cell instance gf180mcu_fd_sc_mcu9t5v0__dffq_1_21 r0 *1 0,0
Xgf180mcu_fd_sc_mcu9t5v0__dffq_1_21 clknet_3_1__leaf_clk \_101_ RxValid VDD
+ DataIn[2] vsubs VSS gf180mcu_fd_sc_mcu9t5v0__dffq_1
* cell instance gf180mcu_fd_sc_mcu9t5v0__dffq_1_22 r0 *1 0,0
Xgf180mcu_fd_sc_mcu9t5v0__dffq_1_22 clknet_3_3__leaf_clk u_sync_detector/_00_
+ u_sync_detector/match[3] VDD VSS vsubs VSS gf180mcu_fd_sc_mcu9t5v0__dffq_1
* cell instance gf180mcu_fd_sc_mcu9t5v0__dffq_1_23 r0 *1 0,0
Xgf180mcu_fd_sc_mcu9t5v0__dffq_1_23 clknet_3_1__leaf_clk \_033_ DataIn[6] VDD
+ gf180mcu_fd_sc_mcu9t5v0__dffq_1_23__VNW vsubs VSS
+ gf180mcu_fd_sc_mcu9t5v0__dffq_1
* cell instance gf180mcu_fd_sc_mcu9t5v0__dffq_1_24 r0 *1 0,0
Xgf180mcu_fd_sc_mcu9t5v0__dffq_1_24 clknet_3_3__leaf_clk \_040_ RxError VDD
+ gf180mcu_fd_sc_mcu9t5v0__dffq_1_24__VNW vsubs VSS
+ gf180mcu_fd_sc_mcu9t5v0__dffq_1
* cell instance gf180mcu_fd_sc_mcu9t5v0__dffq_1_25 r0 *1 0,0
Xgf180mcu_fd_sc_mcu9t5v0__dffq_1_25 clknet_3_3__leaf_clk u_eop_detector/_04_
+ u_eop_detector/se0_count[4] VDD gf180mcu_fd_sc_mcu9t5v0__dffq_1_25__VNW vsubs
+ VSS gf180mcu_fd_sc_mcu9t5v0__dffq_1
* cell instance gf180mcu_fd_sc_mcu9t5v0__dffq_1_26 r0 *1 0,0
Xgf180mcu_fd_sc_mcu9t5v0__dffq_1_26 clknet_3_1__leaf_clk \_039_ byte_reg[6] VDD
+ gf180mcu_fd_sc_mcu9t5v0__dffq_1_26__VNW vsubs VSS
+ gf180mcu_fd_sc_mcu9t5v0__dffq_1
* cell instance gf180mcu_fd_sc_mcu9t5v0__dffq_1_27 r0 *1 0,0
Xgf180mcu_fd_sc_mcu9t5v0__dffq_1_27 clknet_3_1__leaf_clk u_line_state/_1_
+ line_state[1] VDD gf180mcu_fd_sc_mcu9t5v0__dffq_1_27__VNW vsubs VSS
+ gf180mcu_fd_sc_mcu9t5v0__dffq_1
* cell instance gf180mcu_fd_sc_mcu9t5v0__dffq_1_28 r0 *1 0,0
Xgf180mcu_fd_sc_mcu9t5v0__dffq_1_28 clknet_3_3__leaf_clk \_054_ rx_dec_mask VDD
+ gf180mcu_fd_sc_mcu9t5v0__dffq_1_28__VNW vsubs VSS
+ gf180mcu_fd_sc_mcu9t5v0__dffq_1
* cell instance gf180mcu_fd_sc_mcu9t5v0__dffq_1_29 r0 *1 0,0
Xgf180mcu_fd_sc_mcu9t5v0__dffq_1_29 clknet_3_3__leaf_clk u_sync_detector/_04_
+ u_sync_detector/sync_valid VDD gf180mcu_fd_sc_mcu9t5v0__dffq_1_29__VNW vsubs
+ VSS gf180mcu_fd_sc_mcu9t5v0__dffq_1
* cell instance gf180mcu_fd_sc_mcu9t5v0__dffq_1_30 r0 *1 0,0
Xgf180mcu_fd_sc_mcu9t5v0__dffq_1_30 clknet_3_3__leaf_clk u_eop_detector/_07_
+ eop_pulse VDD gf180mcu_fd_sc_mcu9t5v0__dffq_1_30__VNW vsubs VSS
+ gf180mcu_fd_sc_mcu9t5v0__dffq_1
* cell instance gf180mcu_fd_sc_mcu9t5v0__dffq_1_31 r0 *1 0,0
Xgf180mcu_fd_sc_mcu9t5v0__dffq_1_31 clknet_3_1__leaf_clk \_016_ byte_reg[7] VDD
+ DataOut[4] vsubs VSS gf180mcu_fd_sc_mcu9t5v0__dffq_1
* cell instance gf180mcu_fd_sc_mcu9t5v0__dffq_1_32 r0 *1 0,0
Xgf180mcu_fd_sc_mcu9t5v0__dffq_1_32 clknet_3_3__leaf_clk u_eop_detector/_01_
+ u_eop_detector/se0_count[2] VDD gf180mcu_fd_sc_mcu9t5v0__dffq_1_32__VNW vsubs
+ VSS gf180mcu_fd_sc_mcu9t5v0__dffq_1
* cell instance gf180mcu_fd_sc_mcu9t5v0__dffq_1_33 r0 *1 0,0
Xgf180mcu_fd_sc_mcu9t5v0__dffq_1_33 clknet_3_1__leaf_clk u_line_state/_0_
+ line_state[0] VDD VSS vsubs VSS gf180mcu_fd_sc_mcu9t5v0__dffq_1
* cell instance gf180mcu_fd_sc_mcu9t5v0__dffq_1_34 r0 *1 0,0
Xgf180mcu_fd_sc_mcu9t5v0__dffq_1_34 clknet_3_6__leaf_clk \_021_ rx_receiving
+ VDD gf180mcu_fd_sc_mcu9t5v0__dffq_1_34__VNW vsubs VSS
+ gf180mcu_fd_sc_mcu9t5v0__dffq_1
* cell instance gf180mcu_fd_sc_mcu9t5v0__dffq_1_35 r0 *1 0,0
Xgf180mcu_fd_sc_mcu9t5v0__dffq_1_35 clknet_3_4__leaf_clk \_043_ byte_reg[4] VDD
+ gf180mcu_fd_sc_mcu9t5v0__dffq_1_35__VNW vsubs VSS
+ gf180mcu_fd_sc_mcu9t5v0__dffq_1
* cell instance gf180mcu_fd_sc_mcu9t5v0__dffq_1_36 r0 *1 0,0
Xgf180mcu_fd_sc_mcu9t5v0__dffq_1_36 clknet_3_6__leaf_clk u_eop_detector/_00_
+ bus_reset VDD gf180mcu_fd_sc_mcu9t5v0__dffq_1_36__VNW vsubs VSS
+ gf180mcu_fd_sc_mcu9t5v0__dffq_1
* cell instance gf180mcu_fd_sc_mcu9t5v0__dffq_1_37 r0 *1 0,0
Xgf180mcu_fd_sc_mcu9t5v0__dffq_1_37 clknet_3_6__leaf_clk u_eop_detector/_05_
+ u_eop_detector/se0_count[3] VDD gf180mcu_fd_sc_mcu9t5v0__dffq_1_37__VNW vsubs
+ VSS gf180mcu_fd_sc_mcu9t5v0__dffq_1
* cell instance gf180mcu_fd_sc_mcu9t5v0__dffq_1_38 r0 *1 0,0
Xgf180mcu_fd_sc_mcu9t5v0__dffq_1_38 clknet_3_4__leaf_clk \_045_ byte_reg[3] VDD
+ clknet_3_4__leaf_clk vsubs VSS gf180mcu_fd_sc_mcu9t5v0__dffq_1
* cell instance gf180mcu_fd_sc_mcu9t5v0__dffq_1_39 r0 *1 0,0
Xgf180mcu_fd_sc_mcu9t5v0__dffq_1_39 clknet_3_4__leaf_clk \_047_ byte_reg[2] VDD
+ gf180mcu_fd_sc_mcu9t5v0__dffq_1_39__VNW vsubs VSS
+ gf180mcu_fd_sc_mcu9t5v0__dffq_1
* cell instance gf180mcu_fd_sc_mcu9t5v0__dffq_1_40 r0 *1 0,0
Xgf180mcu_fd_sc_mcu9t5v0__dffq_1_40 clknet_3_6__leaf_clk u_eop_detector/_03_
+ u_eop_detector/se0_count[0] VDD u_eop_detector/_18_ vsubs VSS
+ gf180mcu_fd_sc_mcu9t5v0__dffq_1
* cell instance gf180mcu_fd_sc_mcu9t5v0__dffq_1_41 r0 *1 0,0
Xgf180mcu_fd_sc_mcu9t5v0__dffq_1_41 clknet_3_4__leaf_clk \_014_ first_byte VDD
+ \_000_ vsubs VSS gf180mcu_fd_sc_mcu9t5v0__dffq_1
* cell instance gf180mcu_fd_sc_mcu9t5v0__dffq_1_42 r0 *1 0,0
Xgf180mcu_fd_sc_mcu9t5v0__dffq_1_42 clknet_3_6__leaf_clk u_eop_detector/_02_
+ u_eop_detector/se0_count[1] VDD u_eop_detector/_14_ vsubs VSS
+ gf180mcu_fd_sc_mcu9t5v0__dffq_1
* cell instance gf180mcu_fd_sc_mcu9t5v0__dffq_1_43 r0 *1 0,0
Xgf180mcu_fd_sc_mcu9t5v0__dffq_1_43 clknet_3_5__leaf_clk \_051_ byte_reg[0] VDD
+ gf180mcu_fd_sc_mcu9t5v0__dffq_1_43__VNW vsubs VSS
+ gf180mcu_fd_sc_mcu9t5v0__dffq_1
* cell instance gf180mcu_fd_sc_mcu9t5v0__dffq_1_44 r0 *1 0,0
Xgf180mcu_fd_sc_mcu9t5v0__dffq_1_44 clknet_3_7__leaf_clk u_eop_detector/_06_
+ u_eop_detector/se0_count[5] VDD gf180mcu_fd_sc_mcu9t5v0__dffq_1_44__VNW vsubs
+ VSS gf180mcu_fd_sc_mcu9t5v0__dffq_1
* cell instance gf180mcu_fd_sc_mcu9t5v0__dffq_1_45 r0 *1 0,0
Xgf180mcu_fd_sc_mcu9t5v0__dffq_1_45 clknet_3_5__leaf_clk \_049_ byte_reg[1] VDD
+ gf180mcu_fd_sc_mcu9t5v0__dffq_1_45__VNW vsubs VSS
+ gf180mcu_fd_sc_mcu9t5v0__dffq_1
* cell instance gf180mcu_fd_sc_mcu9t5v0__dffq_1_46 r0 *1 0,0
Xgf180mcu_fd_sc_mcu9t5v0__dffq_1_46 clknet_3_7__leaf_clk \_029_ sync_idx[0] VDD
+ gf180mcu_fd_sc_mcu9t5v0__dffq_1_46__VNW vsubs VSS
+ gf180mcu_fd_sc_mcu9t5v0__dffq_1
* cell instance gf180mcu_fd_sc_mcu9t5v0__dffq_1_47 r0 *1 0,0
Xgf180mcu_fd_sc_mcu9t5v0__dffq_1_47 clknet_3_7__leaf_clk \_028_ sync_idx[1] VDD
+ gf180mcu_fd_sc_mcu9t5v0__dffq_1_47__VNW vsubs VSS
+ gf180mcu_fd_sc_mcu9t5v0__dffq_1
* cell instance gf180mcu_fd_sc_mcu9t5v0__dffq_1_48 r0 *1 0,0
Xgf180mcu_fd_sc_mcu9t5v0__dffq_1_48 clknet_3_5__leaf_clk \_042_ byte_reg[5] VDD
+ clknet_3_5__leaf_clk vsubs VSS gf180mcu_fd_sc_mcu9t5v0__dffq_1
* cell instance gf180mcu_fd_sc_mcu9t5v0__dffq_1_49 r0 *1 0,0
Xgf180mcu_fd_sc_mcu9t5v0__dffq_1_49 clknet_3_7__leaf_clk \_050_ sync_idx[2] VDD
+ VSS vsubs VSS gf180mcu_fd_sc_mcu9t5v0__dffq_1
* cell instance gf180mcu_fd_sc_mcu9t5v0__dffq_1_50 r0 *1 0,0
Xgf180mcu_fd_sc_mcu9t5v0__dffq_1_50 clknet_3_5__leaf_clk \_012_ byte_idx[2] VDD
+ gf180mcu_fd_sc_mcu9t5v0__dffq_1_50__VNW vsubs VSS
+ gf180mcu_fd_sc_mcu9t5v0__dffq_1
* cell instance gf180mcu_fd_sc_mcu9t5v0__dffq_1_51 r0 *1 0,0
Xgf180mcu_fd_sc_mcu9t5v0__dffq_1_51 clknet_3_7__leaf_clk \_032_ tx_state[0] VDD
+ gf180mcu_fd_sc_mcu9t5v0__dffq_1_51__VNW vsubs VSS
+ gf180mcu_fd_sc_mcu9t5v0__dffq_1
* cell instance gf180mcu_fd_sc_mcu9t5v0__dffq_1_52 r0 *1 0,0
Xgf180mcu_fd_sc_mcu9t5v0__dffq_1_52 clknet_3_5__leaf_clk \_017_ byte_idx[1] VDD
+ gf180mcu_fd_sc_mcu9t5v0__dffq_1_52__VNW vsubs VSS
+ gf180mcu_fd_sc_mcu9t5v0__dffq_1
* cell instance gf180mcu_fd_sc_mcu9t5v0__dffq_1_53 r0 *1 0,0
Xgf180mcu_fd_sc_mcu9t5v0__dffq_1_53 clknet_3_5__leaf_clk \_018_ byte_idx[0] VDD
+ gf180mcu_fd_sc_mcu9t5v0__dffq_1_53__VNW vsubs VSS
+ gf180mcu_fd_sc_mcu9t5v0__dffq_1
* cell instance gf180mcu_fd_sc_mcu9t5v0__dffq_1_54 r0 *1 0,0
Xgf180mcu_fd_sc_mcu9t5v0__dffq_1_54 clknet_3_7__leaf_clk \_030_ tx_state[1] VDD
+ gf180mcu_fd_sc_mcu9t5v0__dffq_1_54__VNW vsubs VSS
+ gf180mcu_fd_sc_mcu9t5v0__dffq_1
* cell instance gf180mcu_fd_sc_mcu9t5v0__dffq_1_55 r0 *1 0,0
Xgf180mcu_fd_sc_mcu9t5v0__dffq_1_55 clknet_3_7__leaf_clk \_048_ tx_state[2] VDD
+ gf180mcu_fd_sc_mcu9t5v0__dffq_1_55__VNW vsubs VSS
+ gf180mcu_fd_sc_mcu9t5v0__dffq_1
* cell instance gf180mcu_fd_sc_mcu9t5v0__dffrnq_1_0 r0 *1 0,0
Xgf180mcu_fd_sc_mcu9t5v0__dffrnq_1_0 clknet_3_2__leaf_clk u_destuffer/_02_
+ u_destuffer/ones_run[1] rst_n VDD u_destuffer/_13_ vsubs VSS
+ gf180mcu_fd_sc_mcu9t5v0__dffrnq_1
* cell instance gf180mcu_fd_sc_mcu9t5v0__dffrnq_1_1 r0 *1 0,0
Xgf180mcu_fd_sc_mcu9t5v0__dffrnq_1_1 clknet_3_2__leaf_clk u_destuffer/_04_
+ u_destuffer/ones_run[2] rst_n VDD gf180mcu_fd_sc_mcu9t5v0__dffrnq_1_1__VNW
+ vsubs VSS gf180mcu_fd_sc_mcu9t5v0__dffrnq_1
* cell instance gf180mcu_fd_sc_mcu9t5v0__dffrnq_1_2 r0 *1 0,0
Xgf180mcu_fd_sc_mcu9t5v0__dffrnq_1_2 clknet_3_0__leaf_clk u_destuffer/_00_
+ rx_bit_valid rst_n VDD gf180mcu_fd_sc_mcu9t5v0__dffrnq_1_2__VNW vsubs VSS
+ gf180mcu_fd_sc_mcu9t5v0__dffrnq_1
* cell instance gf180mcu_fd_sc_mcu9t5v0__dffrnq_1_3 r0 *1 0,0
Xgf180mcu_fd_sc_mcu9t5v0__dffrnq_1_3 clknet_3_2__leaf_clk u_destuffer/_05_
+ u_destuffer/ones_run[0] rst_n VDD gf180mcu_fd_sc_mcu9t5v0__dffrnq_1_3__VNW
+ vsubs VSS gf180mcu_fd_sc_mcu9t5v0__dffrnq_1
* cell instance gf180mcu_fd_sc_mcu9t5v0__dffrnq_1_4 r0 *1 0,0
Xgf180mcu_fd_sc_mcu9t5v0__dffrnq_1_4 clknet_3_0__leaf_clk u_destuffer/_03_
+ rx_out_bit rst_n VDD gf180mcu_fd_sc_mcu9t5v0__dffrnq_1_4__VNW vsubs VSS
+ gf180mcu_fd_sc_mcu9t5v0__dffrnq_1
* cell instance gf180mcu_fd_sc_mcu9t5v0__dffrnq_1_5 r0 *1 0,0
Xgf180mcu_fd_sc_mcu9t5v0__dffrnq_1_5 clknet_3_2__leaf_clk u_destuffer/_01_
+ rx_stuff_err rst_n VDD \_002_ vsubs VSS gf180mcu_fd_sc_mcu9t5v0__dffrnq_1
* cell instance gf180mcu_fd_sc_mcu9t5v0__dffrnq_1_6 r0 *1 0,0
Xgf180mcu_fd_sc_mcu9t5v0__dffrnq_1_6 clknet_3_2__leaf_clk u_decoder/_02_
+ dec_data_bit rst_n VDD gf180mcu_fd_sc_mcu9t5v0__dffrnq_1_6__VNW vsubs VSS
+ gf180mcu_fd_sc_mcu9t5v0__dffrnq_1
* cell instance gf180mcu_fd_sc_mcu9t5v0__dffrnq_1_7 r0 *1 0,0
Xgf180mcu_fd_sc_mcu9t5v0__dffrnq_1_7 clknet_3_6__leaf_clk u_decoder/_00_
+ dec_data_strobe rst_n VDD gf180mcu_fd_sc_mcu9t5v0__dffrnq_1_7__VNW vsubs VSS
+ gf180mcu_fd_sc_mcu9t5v0__dffrnq_1
* cell instance gf180mcu_fd_sc_mcu9t5v0__dffrnq_1_8 r0 *1 0,0
Xgf180mcu_fd_sc_mcu9t5v0__dffrnq_1_8 clknet_3_6__leaf_clk u_stuffer/_00_
+ u_stuffer/run[0] rst_n VDD gf180mcu_fd_sc_mcu9t5v0__dffrnq_1_8__VNW vsubs VSS
+ gf180mcu_fd_sc_mcu9t5v0__dffrnq_1
* cell instance gf180mcu_fd_sc_mcu9t5v0__dffrnq_1_9 r0 *1 0,0
Xgf180mcu_fd_sc_mcu9t5v0__dffrnq_1_9 clknet_3_6__leaf_clk u_stuffer/_02_
+ u_stuffer/run[2] rst_n VDD gf180mcu_fd_sc_mcu9t5v0__dffrnq_1_9__VNW vsubs VSS
+ gf180mcu_fd_sc_mcu9t5v0__dffrnq_1
* cell instance gf180mcu_fd_sc_mcu9t5v0__dffrnq_1_10 r0 *1 0,0
Xgf180mcu_fd_sc_mcu9t5v0__dffrnq_1_10 clknet_3_6__leaf_clk u_stuffer/_01_
+ u_stuffer/run[1] rst_n VDD gf180mcu_fd_sc_mcu9t5v0__dffrnq_1_10__VNW vsubs
+ VSS gf180mcu_fd_sc_mcu9t5v0__dffrnq_1
* cell instance gf180mcu_fd_sc_mcu9t5v0__dffsnq_1_0 r0 *1 0,0
Xgf180mcu_fd_sc_mcu9t5v0__dffsnq_1_0 clknet_3_3__leaf_clk u_decoder/_01_
+ u_decoder/prev_level rst_n VDD gf180mcu_fd_sc_mcu9t5v0__dffsnq_1_0__VNW vsubs
+ VSS gf180mcu_fd_sc_mcu9t5v0__dffsnq_1
* cell instance gf180mcu_fd_sc_mcu9t5v0__dffsnq_1_1 r0 *1 0,0
Xgf180mcu_fd_sc_mcu9t5v0__dffsnq_1_1 clknet_3_4__leaf_clk u_encoder/_0_
+ nrzi_level rst_n VDD line_state[0] vsubs VSS gf180mcu_fd_sc_mcu9t5v0__dffsnq_1
* cell instance gf180mcu_fd_sc_mcu9t5v0__endcap_0 r0 *1 0,0
Xgf180mcu_fd_sc_mcu9t5v0__endcap_0 VDD VSS gf180mcu_fd_sc_mcu9t5v0__endcap
* cell instance gf180mcu_fd_sc_mcu9t5v0__endcap_1 r0 *1 0,0
Xgf180mcu_fd_sc_mcu9t5v0__endcap_1 VDD VSS gf180mcu_fd_sc_mcu9t5v0__endcap
* cell instance gf180mcu_fd_sc_mcu9t5v0__endcap_2 r0 *1 0,0
Xgf180mcu_fd_sc_mcu9t5v0__endcap_2 VDD VSS gf180mcu_fd_sc_mcu9t5v0__endcap
* cell instance gf180mcu_fd_sc_mcu9t5v0__endcap_3 r0 *1 0,0
Xgf180mcu_fd_sc_mcu9t5v0__endcap_3 VDD VSS gf180mcu_fd_sc_mcu9t5v0__endcap
* cell instance gf180mcu_fd_sc_mcu9t5v0__endcap_4 r0 *1 0,0
Xgf180mcu_fd_sc_mcu9t5v0__endcap_4 VDD VSS gf180mcu_fd_sc_mcu9t5v0__endcap
* cell instance gf180mcu_fd_sc_mcu9t5v0__endcap_5 r0 *1 0,0
Xgf180mcu_fd_sc_mcu9t5v0__endcap_5 VDD VSS gf180mcu_fd_sc_mcu9t5v0__endcap
* cell instance gf180mcu_fd_sc_mcu9t5v0__endcap_6 r0 *1 0,0
Xgf180mcu_fd_sc_mcu9t5v0__endcap_6 VDD VSS gf180mcu_fd_sc_mcu9t5v0__endcap
* cell instance gf180mcu_fd_sc_mcu9t5v0__endcap_7 r0 *1 0,0
Xgf180mcu_fd_sc_mcu9t5v0__endcap_7 VDD VSS gf180mcu_fd_sc_mcu9t5v0__endcap
* cell instance gf180mcu_fd_sc_mcu9t5v0__endcap_8 r0 *1 0,0
Xgf180mcu_fd_sc_mcu9t5v0__endcap_8 VDD VSS gf180mcu_fd_sc_mcu9t5v0__endcap
* cell instance gf180mcu_fd_sc_mcu9t5v0__endcap_9 r0 *1 0,0
Xgf180mcu_fd_sc_mcu9t5v0__endcap_9 VDD VSS gf180mcu_fd_sc_mcu9t5v0__endcap
* cell instance gf180mcu_fd_sc_mcu9t5v0__endcap_10 r0 *1 0,0
Xgf180mcu_fd_sc_mcu9t5v0__endcap_10 VDD VSS gf180mcu_fd_sc_mcu9t5v0__endcap
* cell instance gf180mcu_fd_sc_mcu9t5v0__endcap_11 r0 *1 0,0
Xgf180mcu_fd_sc_mcu9t5v0__endcap_11 VDD VSS gf180mcu_fd_sc_mcu9t5v0__endcap
* cell instance gf180mcu_fd_sc_mcu9t5v0__endcap_12 r0 *1 0,0
Xgf180mcu_fd_sc_mcu9t5v0__endcap_12 VDD VSS gf180mcu_fd_sc_mcu9t5v0__endcap
* cell instance gf180mcu_fd_sc_mcu9t5v0__endcap_13 r0 *1 0,0
Xgf180mcu_fd_sc_mcu9t5v0__endcap_13 VDD VSS gf180mcu_fd_sc_mcu9t5v0__endcap
* cell instance gf180mcu_fd_sc_mcu9t5v0__endcap_14 r0 *1 0,0
Xgf180mcu_fd_sc_mcu9t5v0__endcap_14 VDD VSS gf180mcu_fd_sc_mcu9t5v0__endcap
* cell instance gf180mcu_fd_sc_mcu9t5v0__endcap_15 r0 *1 0,0
Xgf180mcu_fd_sc_mcu9t5v0__endcap_15 VDD VSS gf180mcu_fd_sc_mcu9t5v0__endcap
* cell instance gf180mcu_fd_sc_mcu9t5v0__endcap_16 r0 *1 0,0
Xgf180mcu_fd_sc_mcu9t5v0__endcap_16 VDD VSS gf180mcu_fd_sc_mcu9t5v0__endcap
* cell instance gf180mcu_fd_sc_mcu9t5v0__endcap_17 r0 *1 0,0
Xgf180mcu_fd_sc_mcu9t5v0__endcap_17 VDD VSS gf180mcu_fd_sc_mcu9t5v0__endcap
* cell instance gf180mcu_fd_sc_mcu9t5v0__endcap_18 r0 *1 0,0
Xgf180mcu_fd_sc_mcu9t5v0__endcap_18 VDD VSS gf180mcu_fd_sc_mcu9t5v0__endcap
* cell instance gf180mcu_fd_sc_mcu9t5v0__endcap_19 r0 *1 0,0
Xgf180mcu_fd_sc_mcu9t5v0__endcap_19 VDD VSS gf180mcu_fd_sc_mcu9t5v0__endcap
* cell instance gf180mcu_fd_sc_mcu9t5v0__endcap_20 r0 *1 0,0
Xgf180mcu_fd_sc_mcu9t5v0__endcap_20 VDD VSS gf180mcu_fd_sc_mcu9t5v0__endcap
* cell instance gf180mcu_fd_sc_mcu9t5v0__endcap_21 r0 *1 0,0
Xgf180mcu_fd_sc_mcu9t5v0__endcap_21 VDD VSS gf180mcu_fd_sc_mcu9t5v0__endcap
* cell instance gf180mcu_fd_sc_mcu9t5v0__endcap_22 r0 *1 0,0
Xgf180mcu_fd_sc_mcu9t5v0__endcap_22 VDD VSS gf180mcu_fd_sc_mcu9t5v0__endcap
* cell instance gf180mcu_fd_sc_mcu9t5v0__endcap_23 r0 *1 0,0
Xgf180mcu_fd_sc_mcu9t5v0__endcap_23 VDD VSS gf180mcu_fd_sc_mcu9t5v0__endcap
* cell instance gf180mcu_fd_sc_mcu9t5v0__endcap_24 r0 *1 0,0
Xgf180mcu_fd_sc_mcu9t5v0__endcap_24 VDD VSS gf180mcu_fd_sc_mcu9t5v0__endcap
* cell instance gf180mcu_fd_sc_mcu9t5v0__endcap_25 r0 *1 0,0
Xgf180mcu_fd_sc_mcu9t5v0__endcap_25 VDD VSS gf180mcu_fd_sc_mcu9t5v0__endcap
* cell instance gf180mcu_fd_sc_mcu9t5v0__endcap_26 r0 *1 0,0
Xgf180mcu_fd_sc_mcu9t5v0__endcap_26 VDD VSS gf180mcu_fd_sc_mcu9t5v0__endcap
* cell instance gf180mcu_fd_sc_mcu9t5v0__endcap_27 r0 *1 0,0
Xgf180mcu_fd_sc_mcu9t5v0__endcap_27 VDD VSS gf180mcu_fd_sc_mcu9t5v0__endcap
* cell instance gf180mcu_fd_sc_mcu9t5v0__endcap_28 r0 *1 0,0
Xgf180mcu_fd_sc_mcu9t5v0__endcap_28 VDD VSS gf180mcu_fd_sc_mcu9t5v0__endcap
* cell instance gf180mcu_fd_sc_mcu9t5v0__endcap_29 r0 *1 0,0
Xgf180mcu_fd_sc_mcu9t5v0__endcap_29 VDD VSS gf180mcu_fd_sc_mcu9t5v0__endcap
* cell instance gf180mcu_fd_sc_mcu9t5v0__endcap_30 r0 *1 0,0
Xgf180mcu_fd_sc_mcu9t5v0__endcap_30 VDD VSS gf180mcu_fd_sc_mcu9t5v0__endcap
* cell instance gf180mcu_fd_sc_mcu9t5v0__endcap_31 r0 *1 0,0
Xgf180mcu_fd_sc_mcu9t5v0__endcap_31 VDD VSS gf180mcu_fd_sc_mcu9t5v0__endcap
* cell instance gf180mcu_fd_sc_mcu9t5v0__endcap_32 r0 *1 0,0
Xgf180mcu_fd_sc_mcu9t5v0__endcap_32 VDD VSS gf180mcu_fd_sc_mcu9t5v0__endcap
* cell instance gf180mcu_fd_sc_mcu9t5v0__endcap_33 r0 *1 0,0
Xgf180mcu_fd_sc_mcu9t5v0__endcap_33 VDD VSS gf180mcu_fd_sc_mcu9t5v0__endcap
* cell instance gf180mcu_fd_sc_mcu9t5v0__endcap_34 r0 *1 0,0
Xgf180mcu_fd_sc_mcu9t5v0__endcap_34 VDD VSS gf180mcu_fd_sc_mcu9t5v0__endcap
* cell instance gf180mcu_fd_sc_mcu9t5v0__endcap_35 r0 *1 0,0
Xgf180mcu_fd_sc_mcu9t5v0__endcap_35 VDD VSS gf180mcu_fd_sc_mcu9t5v0__endcap
* cell instance gf180mcu_fd_sc_mcu9t5v0__endcap_36 r0 *1 0,0
Xgf180mcu_fd_sc_mcu9t5v0__endcap_36 VDD VSS gf180mcu_fd_sc_mcu9t5v0__endcap
* cell instance gf180mcu_fd_sc_mcu9t5v0__endcap_37 r0 *1 0,0
Xgf180mcu_fd_sc_mcu9t5v0__endcap_37 VDD VSS gf180mcu_fd_sc_mcu9t5v0__endcap
* cell instance gf180mcu_fd_sc_mcu9t5v0__endcap_38 r0 *1 0,0
Xgf180mcu_fd_sc_mcu9t5v0__endcap_38 VDD VSS gf180mcu_fd_sc_mcu9t5v0__endcap
* cell instance gf180mcu_fd_sc_mcu9t5v0__endcap_39 r0 *1 0,0
Xgf180mcu_fd_sc_mcu9t5v0__endcap_39 VDD VSS gf180mcu_fd_sc_mcu9t5v0__endcap
* cell instance gf180mcu_fd_sc_mcu9t5v0__endcap_40 r0 *1 0,0
Xgf180mcu_fd_sc_mcu9t5v0__endcap_40 VDD VSS gf180mcu_fd_sc_mcu9t5v0__endcap
* cell instance gf180mcu_fd_sc_mcu9t5v0__endcap_41 r0 *1 0,0
Xgf180mcu_fd_sc_mcu9t5v0__endcap_41 VDD VSS gf180mcu_fd_sc_mcu9t5v0__endcap
* cell instance gf180mcu_fd_sc_mcu9t5v0__endcap_42 r0 *1 0,0
Xgf180mcu_fd_sc_mcu9t5v0__endcap_42 VDD VSS gf180mcu_fd_sc_mcu9t5v0__endcap
* cell instance gf180mcu_fd_sc_mcu9t5v0__endcap_43 r0 *1 0,0
Xgf180mcu_fd_sc_mcu9t5v0__endcap_43 VDD VSS gf180mcu_fd_sc_mcu9t5v0__endcap
* cell instance gf180mcu_fd_sc_mcu9t5v0__endcap_44 r0 *1 0,0
Xgf180mcu_fd_sc_mcu9t5v0__endcap_44 VDD VSS gf180mcu_fd_sc_mcu9t5v0__endcap
* cell instance gf180mcu_fd_sc_mcu9t5v0__endcap_45 r0 *1 0,0
Xgf180mcu_fd_sc_mcu9t5v0__endcap_45 VDD VSS gf180mcu_fd_sc_mcu9t5v0__endcap
* cell instance gf180mcu_fd_sc_mcu9t5v0__endcap_46 r0 *1 0,0
Xgf180mcu_fd_sc_mcu9t5v0__endcap_46 VDD VSS gf180mcu_fd_sc_mcu9t5v0__endcap
* cell instance gf180mcu_fd_sc_mcu9t5v0__endcap_47 r0 *1 0,0
Xgf180mcu_fd_sc_mcu9t5v0__endcap_47 VDD VSS gf180mcu_fd_sc_mcu9t5v0__endcap
* cell instance gf180mcu_fd_sc_mcu9t5v0__endcap_48 r0 *1 0,0
Xgf180mcu_fd_sc_mcu9t5v0__endcap_48 VDD VSS gf180mcu_fd_sc_mcu9t5v0__endcap
* cell instance gf180mcu_fd_sc_mcu9t5v0__endcap_49 r0 *1 0,0
Xgf180mcu_fd_sc_mcu9t5v0__endcap_49 VDD VSS gf180mcu_fd_sc_mcu9t5v0__endcap
* cell instance gf180mcu_fd_sc_mcu9t5v0__endcap_50 r0 *1 0,0
Xgf180mcu_fd_sc_mcu9t5v0__endcap_50 VDD VSS gf180mcu_fd_sc_mcu9t5v0__endcap
* cell instance gf180mcu_fd_sc_mcu9t5v0__endcap_51 r0 *1 0,0
Xgf180mcu_fd_sc_mcu9t5v0__endcap_51 VDD VSS gf180mcu_fd_sc_mcu9t5v0__endcap
* cell instance gf180mcu_fd_sc_mcu9t5v0__endcap_52 r0 *1 0,0
Xgf180mcu_fd_sc_mcu9t5v0__endcap_52 VDD VSS gf180mcu_fd_sc_mcu9t5v0__endcap
* cell instance gf180mcu_fd_sc_mcu9t5v0__endcap_53 r0 *1 0,0
Xgf180mcu_fd_sc_mcu9t5v0__endcap_53 VDD VSS gf180mcu_fd_sc_mcu9t5v0__endcap
* cell instance gf180mcu_fd_sc_mcu9t5v0__endcap_54 r0 *1 0,0
Xgf180mcu_fd_sc_mcu9t5v0__endcap_54 VDD VSS gf180mcu_fd_sc_mcu9t5v0__endcap
* cell instance gf180mcu_fd_sc_mcu9t5v0__endcap_55 r0 *1 0,0
Xgf180mcu_fd_sc_mcu9t5v0__endcap_55 VDD VSS gf180mcu_fd_sc_mcu9t5v0__endcap
* cell instance gf180mcu_fd_sc_mcu9t5v0__endcap_56 r0 *1 0,0
Xgf180mcu_fd_sc_mcu9t5v0__endcap_56 VDD VSS gf180mcu_fd_sc_mcu9t5v0__endcap
* cell instance gf180mcu_fd_sc_mcu9t5v0__endcap_57 r0 *1 0,0
Xgf180mcu_fd_sc_mcu9t5v0__endcap_57 VDD VSS gf180mcu_fd_sc_mcu9t5v0__endcap
* cell instance gf180mcu_fd_sc_mcu9t5v0__endcap_58 r0 *1 0,0
Xgf180mcu_fd_sc_mcu9t5v0__endcap_58 VDD VSS gf180mcu_fd_sc_mcu9t5v0__endcap
* cell instance gf180mcu_fd_sc_mcu9t5v0__endcap_59 r0 *1 0,0
Xgf180mcu_fd_sc_mcu9t5v0__endcap_59 VDD VSS gf180mcu_fd_sc_mcu9t5v0__endcap
* cell instance gf180mcu_fd_sc_mcu9t5v0__endcap_60 r0 *1 0,0
Xgf180mcu_fd_sc_mcu9t5v0__endcap_60 VDD VSS gf180mcu_fd_sc_mcu9t5v0__endcap
* cell instance gf180mcu_fd_sc_mcu9t5v0__endcap_61 r0 *1 0,0
Xgf180mcu_fd_sc_mcu9t5v0__endcap_61 VDD VSS gf180mcu_fd_sc_mcu9t5v0__endcap
* cell instance gf180mcu_fd_sc_mcu9t5v0__endcap_62 r0 *1 0,0
Xgf180mcu_fd_sc_mcu9t5v0__endcap_62 VDD VSS gf180mcu_fd_sc_mcu9t5v0__endcap
* cell instance gf180mcu_fd_sc_mcu9t5v0__endcap_63 r0 *1 0,0
Xgf180mcu_fd_sc_mcu9t5v0__endcap_63 VDD VSS gf180mcu_fd_sc_mcu9t5v0__endcap
* cell instance gf180mcu_fd_sc_mcu9t5v0__endcap_64 r0 *1 0,0
Xgf180mcu_fd_sc_mcu9t5v0__endcap_64 VDD VSS gf180mcu_fd_sc_mcu9t5v0__endcap
* cell instance gf180mcu_fd_sc_mcu9t5v0__endcap_65 r0 *1 0,0
Xgf180mcu_fd_sc_mcu9t5v0__endcap_65 VDD VSS gf180mcu_fd_sc_mcu9t5v0__endcap
* cell instance gf180mcu_fd_sc_mcu9t5v0__endcap_66 r0 *1 0,0
Xgf180mcu_fd_sc_mcu9t5v0__endcap_66 VDD VSS gf180mcu_fd_sc_mcu9t5v0__endcap
* cell instance gf180mcu_fd_sc_mcu9t5v0__endcap_67 r0 *1 0,0
Xgf180mcu_fd_sc_mcu9t5v0__endcap_67 VDD VSS gf180mcu_fd_sc_mcu9t5v0__endcap
* cell instance gf180mcu_fd_sc_mcu9t5v0__endcap_68 r0 *1 0,0
Xgf180mcu_fd_sc_mcu9t5v0__endcap_68 VDD VSS gf180mcu_fd_sc_mcu9t5v0__endcap
* cell instance gf180mcu_fd_sc_mcu9t5v0__endcap_69 r0 *1 0,0
Xgf180mcu_fd_sc_mcu9t5v0__endcap_69 VDD VSS gf180mcu_fd_sc_mcu9t5v0__endcap
* cell instance gf180mcu_fd_sc_mcu9t5v0__fill_1_0 r0 *1 0,0
Xgf180mcu_fd_sc_mcu9t5v0__fill_1_0 VDD gf180mcu_fd_sc_mcu9t5v0__fill_1_0__VNW
+ gf180mcu_fd_sc_mcu9t5v0__fill_1_0__VPW VSS gf180mcu_fd_sc_mcu9t5v0__fill_1
* cell instance gf180mcu_fd_sc_mcu9t5v0__fill_1_1 r0 *1 0,0
Xgf180mcu_fd_sc_mcu9t5v0__fill_1_1 VDD gf180mcu_fd_sc_mcu9t5v0__fill_1_1__VNW
+ gf180mcu_fd_sc_mcu9t5v0__fill_1_1__VPW VSS gf180mcu_fd_sc_mcu9t5v0__fill_1
* cell instance gf180mcu_fd_sc_mcu9t5v0__fill_1_2 r0 *1 0,0
Xgf180mcu_fd_sc_mcu9t5v0__fill_1_2 VDD gf180mcu_fd_sc_mcu9t5v0__fill_1_2__VNW
+ gf180mcu_fd_sc_mcu9t5v0__fill_1_2__VPW VSS gf180mcu_fd_sc_mcu9t5v0__fill_1
* cell instance gf180mcu_fd_sc_mcu9t5v0__fill_1_3 r0 *1 0,0
Xgf180mcu_fd_sc_mcu9t5v0__fill_1_3 VDD gf180mcu_fd_sc_mcu9t5v0__fill_1_3__VNW
+ gf180mcu_fd_sc_mcu9t5v0__fill_1_3__VPW VSS gf180mcu_fd_sc_mcu9t5v0__fill_1
* cell instance gf180mcu_fd_sc_mcu9t5v0__fill_1_4 r0 *1 0,0
Xgf180mcu_fd_sc_mcu9t5v0__fill_1_4 VDD gf180mcu_fd_sc_mcu9t5v0__fill_1_4__VNW
+ gf180mcu_fd_sc_mcu9t5v0__fill_1_4__VPW VSS gf180mcu_fd_sc_mcu9t5v0__fill_1
* cell instance gf180mcu_fd_sc_mcu9t5v0__fill_1_5 r0 *1 0,0
Xgf180mcu_fd_sc_mcu9t5v0__fill_1_5 VDD VSS
+ gf180mcu_fd_sc_mcu9t5v0__fill_1_5__VPW VSS gf180mcu_fd_sc_mcu9t5v0__fill_1
* cell instance gf180mcu_fd_sc_mcu9t5v0__fill_1_6 r0 *1 0,0
Xgf180mcu_fd_sc_mcu9t5v0__fill_1_6 VDD gf180mcu_fd_sc_mcu9t5v0__fill_1_6__VNW
+ gf180mcu_fd_sc_mcu9t5v0__fill_1_6__VPW VSS gf180mcu_fd_sc_mcu9t5v0__fill_1
* cell instance gf180mcu_fd_sc_mcu9t5v0__fill_1_7 r0 *1 0,0
Xgf180mcu_fd_sc_mcu9t5v0__fill_1_7 VDD \_117_
+ gf180mcu_fd_sc_mcu9t5v0__fill_1_7__VPW VSS gf180mcu_fd_sc_mcu9t5v0__fill_1
* cell instance gf180mcu_fd_sc_mcu9t5v0__fill_1_8 r0 *1 0,0
Xgf180mcu_fd_sc_mcu9t5v0__fill_1_8 VDD gf180mcu_fd_sc_mcu9t5v0__fill_1_8__VNW
+ gf180mcu_fd_sc_mcu9t5v0__fill_1_8__VPW VSS gf180mcu_fd_sc_mcu9t5v0__fill_1
* cell instance gf180mcu_fd_sc_mcu9t5v0__fill_1_9 r0 *1 0,0
Xgf180mcu_fd_sc_mcu9t5v0__fill_1_9 VDD VSS VSS VSS
+ gf180mcu_fd_sc_mcu9t5v0__fill_1
* cell instance gf180mcu_fd_sc_mcu9t5v0__fill_1_10 r0 *1 0,0
Xgf180mcu_fd_sc_mcu9t5v0__fill_1_10 VDD VSS VSS VSS
+ gf180mcu_fd_sc_mcu9t5v0__fill_1
* cell instance gf180mcu_fd_sc_mcu9t5v0__fill_1_11 r0 *1 0,0
Xgf180mcu_fd_sc_mcu9t5v0__fill_1_11 VDD \_116_ VSS VSS
+ gf180mcu_fd_sc_mcu9t5v0__fill_1
* cell instance gf180mcu_fd_sc_mcu9t5v0__fill_1_12 r0 *1 0,0
Xgf180mcu_fd_sc_mcu9t5v0__fill_1_12 VDD VSS VSS VSS
+ gf180mcu_fd_sc_mcu9t5v0__fill_1
* cell instance gf180mcu_fd_sc_mcu9t5v0__fill_1_13 r0 *1 0,0
Xgf180mcu_fd_sc_mcu9t5v0__fill_1_13 VDD gf180mcu_fd_sc_mcu9t5v0__fill_1_13__VNW
+ gf180mcu_fd_sc_mcu9t5v0__fill_1_13__VPW VSS gf180mcu_fd_sc_mcu9t5v0__fill_1
* cell instance gf180mcu_fd_sc_mcu9t5v0__fill_1_14 r0 *1 0,0
Xgf180mcu_fd_sc_mcu9t5v0__fill_1_14 VDD VDD VDD VSS
+ gf180mcu_fd_sc_mcu9t5v0__fill_1
* cell instance gf180mcu_fd_sc_mcu9t5v0__fill_1_15 r0 *1 0,0
Xgf180mcu_fd_sc_mcu9t5v0__fill_1_15 VDD VDD VDD VSS
+ gf180mcu_fd_sc_mcu9t5v0__fill_1
* cell instance gf180mcu_fd_sc_mcu9t5v0__fill_1_16 r0 *1 0,0
Xgf180mcu_fd_sc_mcu9t5v0__fill_1_16 VDD VDD VDD VSS
+ gf180mcu_fd_sc_mcu9t5v0__fill_1
* cell instance gf180mcu_fd_sc_mcu9t5v0__fill_1_17 r0 *1 0,0
Xgf180mcu_fd_sc_mcu9t5v0__fill_1_17 VDD VDD VDD VSS
+ gf180mcu_fd_sc_mcu9t5v0__fill_1
* cell instance gf180mcu_fd_sc_mcu9t5v0__fill_1_18 r0 *1 0,0
Xgf180mcu_fd_sc_mcu9t5v0__fill_1_18 VDD VDD VDD VSS
+ gf180mcu_fd_sc_mcu9t5v0__fill_1
* cell instance gf180mcu_fd_sc_mcu9t5v0__fill_1_19 r0 *1 0,0
Xgf180mcu_fd_sc_mcu9t5v0__fill_1_19 VDD gf180mcu_fd_sc_mcu9t5v0__fill_1_19__VNW
+ gf180mcu_fd_sc_mcu9t5v0__fill_1_19__VPW VSS gf180mcu_fd_sc_mcu9t5v0__fill_1
* cell instance gf180mcu_fd_sc_mcu9t5v0__fill_1_20 r0 *1 0,0
Xgf180mcu_fd_sc_mcu9t5v0__fill_1_20 VDD u_sync_detector/_03_
+ gf180mcu_fd_sc_mcu9t5v0__fill_1_20__VPW VSS gf180mcu_fd_sc_mcu9t5v0__fill_1
* cell instance gf180mcu_fd_sc_mcu9t5v0__fill_1_21 r0 *1 0,0
Xgf180mcu_fd_sc_mcu9t5v0__fill_1_21 VDD \_125_
+ gf180mcu_fd_sc_mcu9t5v0__fill_1_21__VPW VSS gf180mcu_fd_sc_mcu9t5v0__fill_1
* cell instance gf180mcu_fd_sc_mcu9t5v0__fill_1_22 r0 *1 0,0
Xgf180mcu_fd_sc_mcu9t5v0__fill_1_22 VDD clknet_3_0__leaf_clk
+ gf180mcu_fd_sc_mcu9t5v0__fill_1_22__VPW VSS gf180mcu_fd_sc_mcu9t5v0__fill_1
* cell instance gf180mcu_fd_sc_mcu9t5v0__fill_1_23 r0 *1 0,0
Xgf180mcu_fd_sc_mcu9t5v0__fill_1_23 VDD gf180mcu_fd_sc_mcu9t5v0__fill_1_23__VNW
+ gf180mcu_fd_sc_mcu9t5v0__fill_1_23__VPW VSS gf180mcu_fd_sc_mcu9t5v0__fill_1
* cell instance gf180mcu_fd_sc_mcu9t5v0__fill_1_24 r0 *1 0,0
Xgf180mcu_fd_sc_mcu9t5v0__fill_1_24 VDD VSS
+ gf180mcu_fd_sc_mcu9t5v0__fill_1_24__VPW VSS gf180mcu_fd_sc_mcu9t5v0__fill_1
* cell instance gf180mcu_fd_sc_mcu9t5v0__fill_1_25 r0 *1 0,0
Xgf180mcu_fd_sc_mcu9t5v0__fill_1_25 VDD gf180mcu_fd_sc_mcu9t5v0__fill_1_25__VNW
+ gf180mcu_fd_sc_mcu9t5v0__fill_1_25__VPW VSS gf180mcu_fd_sc_mcu9t5v0__fill_1
* cell instance gf180mcu_fd_sc_mcu9t5v0__fill_1_26 r0 *1 0,0
Xgf180mcu_fd_sc_mcu9t5v0__fill_1_26 VDD gf180mcu_fd_sc_mcu9t5v0__fill_1_26__VNW
+ gf180mcu_fd_sc_mcu9t5v0__fill_1_26__VPW VSS gf180mcu_fd_sc_mcu9t5v0__fill_1
* cell instance gf180mcu_fd_sc_mcu9t5v0__fill_1_27 r0 *1 0,0
Xgf180mcu_fd_sc_mcu9t5v0__fill_1_27 VDD gf180mcu_fd_sc_mcu9t5v0__fill_1_27__VNW
+ gf180mcu_fd_sc_mcu9t5v0__fill_1_27__VPW VSS gf180mcu_fd_sc_mcu9t5v0__fill_1
* cell instance gf180mcu_fd_sc_mcu9t5v0__fill_1_28 r0 *1 0,0
Xgf180mcu_fd_sc_mcu9t5v0__fill_1_28 VDD gf180mcu_fd_sc_mcu9t5v0__fill_1_28__VNW
+ gf180mcu_fd_sc_mcu9t5v0__fill_1_28__VPW VSS gf180mcu_fd_sc_mcu9t5v0__fill_1
* cell instance gf180mcu_fd_sc_mcu9t5v0__fill_1_29 r0 *1 0,0
Xgf180mcu_fd_sc_mcu9t5v0__fill_1_29 VDD gf180mcu_fd_sc_mcu9t5v0__fill_1_29__VNW
+ gf180mcu_fd_sc_mcu9t5v0__fill_1_29__VPW VSS gf180mcu_fd_sc_mcu9t5v0__fill_1
* cell instance gf180mcu_fd_sc_mcu9t5v0__fill_1_30 r0 *1 0,0
Xgf180mcu_fd_sc_mcu9t5v0__fill_1_30 VDD gf180mcu_fd_sc_mcu9t5v0__fill_1_30__VNW
+ gf180mcu_fd_sc_mcu9t5v0__fill_1_30__VPW VSS gf180mcu_fd_sc_mcu9t5v0__fill_1
* cell instance gf180mcu_fd_sc_mcu9t5v0__fill_1_31 r0 *1 0,0
Xgf180mcu_fd_sc_mcu9t5v0__fill_1_31 VDD VSS
+ gf180mcu_fd_sc_mcu9t5v0__fill_1_31__VPW VSS gf180mcu_fd_sc_mcu9t5v0__fill_1
* cell instance gf180mcu_fd_sc_mcu9t5v0__fill_1_32 r0 *1 0,0
Xgf180mcu_fd_sc_mcu9t5v0__fill_1_32 VDD gf180mcu_fd_sc_mcu9t5v0__fill_1_32__VNW
+ gf180mcu_fd_sc_mcu9t5v0__fill_1_32__VPW VSS gf180mcu_fd_sc_mcu9t5v0__fill_1
* cell instance gf180mcu_fd_sc_mcu9t5v0__fill_1_33 r0 *1 0,0
Xgf180mcu_fd_sc_mcu9t5v0__fill_1_33 VDD gf180mcu_fd_sc_mcu9t5v0__fill_1_33__VNW
+ gf180mcu_fd_sc_mcu9t5v0__fill_1_33__VPW VSS gf180mcu_fd_sc_mcu9t5v0__fill_1
* cell instance gf180mcu_fd_sc_mcu9t5v0__fill_1_34 r0 *1 0,0
Xgf180mcu_fd_sc_mcu9t5v0__fill_1_34 VDD gf180mcu_fd_sc_mcu9t5v0__fill_1_34__VNW
+ gf180mcu_fd_sc_mcu9t5v0__fill_1_34__VPW VSS gf180mcu_fd_sc_mcu9t5v0__fill_1
* cell instance gf180mcu_fd_sc_mcu9t5v0__fill_1_35 r0 *1 0,0
Xgf180mcu_fd_sc_mcu9t5v0__fill_1_35 VDD \_056_
+ gf180mcu_fd_sc_mcu9t5v0__fill_1_35__VPW VSS gf180mcu_fd_sc_mcu9t5v0__fill_1
* cell instance gf180mcu_fd_sc_mcu9t5v0__fill_1_36 r0 *1 0,0
Xgf180mcu_fd_sc_mcu9t5v0__fill_1_36 VDD gf180mcu_fd_sc_mcu9t5v0__fill_1_36__VNW
+ gf180mcu_fd_sc_mcu9t5v0__fill_1_36__VPW VSS gf180mcu_fd_sc_mcu9t5v0__fill_1
* cell instance gf180mcu_fd_sc_mcu9t5v0__fill_1_37 r0 *1 0,0
Xgf180mcu_fd_sc_mcu9t5v0__fill_1_37 VDD gf180mcu_fd_sc_mcu9t5v0__fill_1_37__VNW
+ gf180mcu_fd_sc_mcu9t5v0__fill_1_37__VPW VSS gf180mcu_fd_sc_mcu9t5v0__fill_1
* cell instance gf180mcu_fd_sc_mcu9t5v0__fill_1_38 r0 *1 0,0
Xgf180mcu_fd_sc_mcu9t5v0__fill_1_38 VDD gf180mcu_fd_sc_mcu9t5v0__fill_1_38__VNW
+ VDD VSS gf180mcu_fd_sc_mcu9t5v0__fill_1
* cell instance gf180mcu_fd_sc_mcu9t5v0__fill_1_39 r0 *1 0,0
Xgf180mcu_fd_sc_mcu9t5v0__fill_1_39 VDD gf180mcu_fd_sc_mcu9t5v0__fill_1_39__VNW
+ gf180mcu_fd_sc_mcu9t5v0__fill_1_39__VPW VSS gf180mcu_fd_sc_mcu9t5v0__fill_1
* cell instance gf180mcu_fd_sc_mcu9t5v0__fill_1_40 r0 *1 0,0
Xgf180mcu_fd_sc_mcu9t5v0__fill_1_40 VDD gf180mcu_fd_sc_mcu9t5v0__fill_1_40__VNW
+ gf180mcu_fd_sc_mcu9t5v0__fill_1_40__VPW VSS gf180mcu_fd_sc_mcu9t5v0__fill_1
* cell instance gf180mcu_fd_sc_mcu9t5v0__fill_1_41 r0 *1 0,0
Xgf180mcu_fd_sc_mcu9t5v0__fill_1_41 VDD rx_shift[1]
+ gf180mcu_fd_sc_mcu9t5v0__fill_1_41__VPW VSS gf180mcu_fd_sc_mcu9t5v0__fill_1
* cell instance gf180mcu_fd_sc_mcu9t5v0__fill_1_42 r0 *1 0,0
Xgf180mcu_fd_sc_mcu9t5v0__fill_1_42 VDD gf180mcu_fd_sc_mcu9t5v0__fill_1_42__VNW
+ gf180mcu_fd_sc_mcu9t5v0__fill_1_42__VPW VSS gf180mcu_fd_sc_mcu9t5v0__fill_1
* cell instance gf180mcu_fd_sc_mcu9t5v0__fill_1_43 r0 *1 0,0
Xgf180mcu_fd_sc_mcu9t5v0__fill_1_43 VDD gf180mcu_fd_sc_mcu9t5v0__fill_1_43__VNW
+ VDD VSS gf180mcu_fd_sc_mcu9t5v0__fill_1
* cell instance gf180mcu_fd_sc_mcu9t5v0__fill_1_44 r0 *1 0,0
Xgf180mcu_fd_sc_mcu9t5v0__fill_1_44 VDD gf180mcu_fd_sc_mcu9t5v0__fill_1_44__VNW
+ gf180mcu_fd_sc_mcu9t5v0__fill_1_44__VPW VSS gf180mcu_fd_sc_mcu9t5v0__fill_1
* cell instance gf180mcu_fd_sc_mcu9t5v0__fill_1_45 r0 *1 0,0
Xgf180mcu_fd_sc_mcu9t5v0__fill_1_45 VDD VSS VSS VSS
+ gf180mcu_fd_sc_mcu9t5v0__fill_1
* cell instance gf180mcu_fd_sc_mcu9t5v0__fill_1_46 r0 *1 0,0
Xgf180mcu_fd_sc_mcu9t5v0__fill_1_46 VDD VSS VSS VSS
+ gf180mcu_fd_sc_mcu9t5v0__fill_1
* cell instance gf180mcu_fd_sc_mcu9t5v0__fill_1_47 r0 *1 0,0
Xgf180mcu_fd_sc_mcu9t5v0__fill_1_47 VDD DataIn[2] VDD VSS
+ gf180mcu_fd_sc_mcu9t5v0__fill_1
* cell instance gf180mcu_fd_sc_mcu9t5v0__fill_1_48 r0 *1 0,0
Xgf180mcu_fd_sc_mcu9t5v0__fill_1_48 VDD VDD VDD VSS
+ gf180mcu_fd_sc_mcu9t5v0__fill_1
* cell instance gf180mcu_fd_sc_mcu9t5v0__fill_1_49 r0 *1 0,0
Xgf180mcu_fd_sc_mcu9t5v0__fill_1_49 VDD VDD VDD VSS
+ gf180mcu_fd_sc_mcu9t5v0__fill_1
* cell instance gf180mcu_fd_sc_mcu9t5v0__fill_1_50 r0 *1 0,0
Xgf180mcu_fd_sc_mcu9t5v0__fill_1_50 VDD VDD VDD VSS
+ gf180mcu_fd_sc_mcu9t5v0__fill_1
* cell instance gf180mcu_fd_sc_mcu9t5v0__fill_1_51 r0 *1 0,0
Xgf180mcu_fd_sc_mcu9t5v0__fill_1_51 VDD RxError
+ gf180mcu_fd_sc_mcu9t5v0__fill_1_51__VPW VSS gf180mcu_fd_sc_mcu9t5v0__fill_1
* cell instance gf180mcu_fd_sc_mcu9t5v0__fill_1_52 r0 *1 0,0
Xgf180mcu_fd_sc_mcu9t5v0__fill_1_52 VDD VDD VDD VSS
+ gf180mcu_fd_sc_mcu9t5v0__fill_1
* cell instance gf180mcu_fd_sc_mcu9t5v0__fill_1_53 r0 *1 0,0
Xgf180mcu_fd_sc_mcu9t5v0__fill_1_53 VDD VDD VDD VSS
+ gf180mcu_fd_sc_mcu9t5v0__fill_1
* cell instance gf180mcu_fd_sc_mcu9t5v0__fill_1_54 r0 *1 0,0
Xgf180mcu_fd_sc_mcu9t5v0__fill_1_54 VDD VDD VDD VSS
+ gf180mcu_fd_sc_mcu9t5v0__fill_1
* cell instance gf180mcu_fd_sc_mcu9t5v0__fill_1_55 r0 *1 0,0
Xgf180mcu_fd_sc_mcu9t5v0__fill_1_55 VDD VDD VDD VSS
+ gf180mcu_fd_sc_mcu9t5v0__fill_1
* cell instance gf180mcu_fd_sc_mcu9t5v0__fill_1_56 r0 *1 0,0
Xgf180mcu_fd_sc_mcu9t5v0__fill_1_56 VDD gf180mcu_fd_sc_mcu9t5v0__fill_1_56__VNW
+ gf180mcu_fd_sc_mcu9t5v0__fill_1_56__VPW VSS gf180mcu_fd_sc_mcu9t5v0__fill_1
* cell instance gf180mcu_fd_sc_mcu9t5v0__fill_1_57 r0 *1 0,0
Xgf180mcu_fd_sc_mcu9t5v0__fill_1_57 VDD gf180mcu_fd_sc_mcu9t5v0__fill_1_57__VNW
+ gf180mcu_fd_sc_mcu9t5v0__fill_1_57__VPW VSS gf180mcu_fd_sc_mcu9t5v0__fill_1
* cell instance gf180mcu_fd_sc_mcu9t5v0__fill_1_58 r0 *1 0,0
Xgf180mcu_fd_sc_mcu9t5v0__fill_1_58 VDD gf180mcu_fd_sc_mcu9t5v0__fill_1_58__VNW
+ gf180mcu_fd_sc_mcu9t5v0__fill_1_58__VPW VSS gf180mcu_fd_sc_mcu9t5v0__fill_1
* cell instance gf180mcu_fd_sc_mcu9t5v0__fill_1_59 r0 *1 0,0
Xgf180mcu_fd_sc_mcu9t5v0__fill_1_59 VDD gf180mcu_fd_sc_mcu9t5v0__fill_1_59__VNW
+ gf180mcu_fd_sc_mcu9t5v0__fill_1_59__VPW VSS gf180mcu_fd_sc_mcu9t5v0__fill_1
* cell instance gf180mcu_fd_sc_mcu9t5v0__fill_1_60 r0 *1 0,0
Xgf180mcu_fd_sc_mcu9t5v0__fill_1_60 VDD gf180mcu_fd_sc_mcu9t5v0__fill_1_60__VNW
+ gf180mcu_fd_sc_mcu9t5v0__fill_1_60__VPW VSS gf180mcu_fd_sc_mcu9t5v0__fill_1
* cell instance gf180mcu_fd_sc_mcu9t5v0__fill_1_61 r0 *1 0,0
Xgf180mcu_fd_sc_mcu9t5v0__fill_1_61 VDD gf180mcu_fd_sc_mcu9t5v0__fill_1_61__VNW
+ gf180mcu_fd_sc_mcu9t5v0__fill_1_61__VPW VSS gf180mcu_fd_sc_mcu9t5v0__fill_1
* cell instance gf180mcu_fd_sc_mcu9t5v0__fill_1_62 r0 *1 0,0
Xgf180mcu_fd_sc_mcu9t5v0__fill_1_62 VDD gf180mcu_fd_sc_mcu9t5v0__fill_1_62__VNW
+ gf180mcu_fd_sc_mcu9t5v0__fill_1_62__VPW VSS gf180mcu_fd_sc_mcu9t5v0__fill_1
* cell instance gf180mcu_fd_sc_mcu9t5v0__fill_1_63 r0 *1 0,0
Xgf180mcu_fd_sc_mcu9t5v0__fill_1_63 VDD DataIn[2]
+ gf180mcu_fd_sc_mcu9t5v0__fill_1_63__VPW VSS gf180mcu_fd_sc_mcu9t5v0__fill_1
* cell instance gf180mcu_fd_sc_mcu9t5v0__fill_1_64 r0 *1 0,0
Xgf180mcu_fd_sc_mcu9t5v0__fill_1_64 VDD gf180mcu_fd_sc_mcu9t5v0__fill_1_64__VNW
+ gf180mcu_fd_sc_mcu9t5v0__fill_1_64__VPW VSS gf180mcu_fd_sc_mcu9t5v0__fill_1
* cell instance gf180mcu_fd_sc_mcu9t5v0__fill_1_65 r0 *1 0,0
Xgf180mcu_fd_sc_mcu9t5v0__fill_1_65 VDD gf180mcu_fd_sc_mcu9t5v0__fill_1_65__VNW
+ gf180mcu_fd_sc_mcu9t5v0__fill_1_65__VPW VSS gf180mcu_fd_sc_mcu9t5v0__fill_1
* cell instance gf180mcu_fd_sc_mcu9t5v0__fill_1_66 r0 *1 0,0
Xgf180mcu_fd_sc_mcu9t5v0__fill_1_66 VDD gf180mcu_fd_sc_mcu9t5v0__fill_1_66__VNW
+ gf180mcu_fd_sc_mcu9t5v0__fill_1_66__VPW VSS gf180mcu_fd_sc_mcu9t5v0__fill_1
* cell instance gf180mcu_fd_sc_mcu9t5v0__fill_1_67 r0 *1 0,0
Xgf180mcu_fd_sc_mcu9t5v0__fill_1_67 VDD DataIn[2]
+ gf180mcu_fd_sc_mcu9t5v0__fill_1_67__VPW VSS gf180mcu_fd_sc_mcu9t5v0__fill_1
* cell instance gf180mcu_fd_sc_mcu9t5v0__fill_1_68 r0 *1 0,0
Xgf180mcu_fd_sc_mcu9t5v0__fill_1_68 VDD gf180mcu_fd_sc_mcu9t5v0__fill_1_68__VNW
+ VDD VSS gf180mcu_fd_sc_mcu9t5v0__fill_1
* cell instance gf180mcu_fd_sc_mcu9t5v0__fill_1_69 r0 *1 0,0
Xgf180mcu_fd_sc_mcu9t5v0__fill_1_69 VDD gf180mcu_fd_sc_mcu9t5v0__fill_1_69__VNW
+ gf180mcu_fd_sc_mcu9t5v0__fill_1_69__VPW VSS gf180mcu_fd_sc_mcu9t5v0__fill_1
* cell instance gf180mcu_fd_sc_mcu9t5v0__fill_1_70 r0 *1 0,0
Xgf180mcu_fd_sc_mcu9t5v0__fill_1_70 VDD gf180mcu_fd_sc_mcu9t5v0__fill_1_70__VNW
+ gf180mcu_fd_sc_mcu9t5v0__fill_1_70__VPW VSS gf180mcu_fd_sc_mcu9t5v0__fill_1
* cell instance gf180mcu_fd_sc_mcu9t5v0__fill_1_71 r0 *1 0,0
Xgf180mcu_fd_sc_mcu9t5v0__fill_1_71 VDD byte_reg[7]
+ gf180mcu_fd_sc_mcu9t5v0__fill_1_71__VPW VSS gf180mcu_fd_sc_mcu9t5v0__fill_1
* cell instance gf180mcu_fd_sc_mcu9t5v0__fill_1_72 r0 *1 0,0
Xgf180mcu_fd_sc_mcu9t5v0__fill_1_72 VDD gf180mcu_fd_sc_mcu9t5v0__fill_1_72__VNW
+ gf180mcu_fd_sc_mcu9t5v0__fill_1_72__VPW VSS gf180mcu_fd_sc_mcu9t5v0__fill_1
* cell instance gf180mcu_fd_sc_mcu9t5v0__fill_1_73 r0 *1 0,0
Xgf180mcu_fd_sc_mcu9t5v0__fill_1_73 VDD gf180mcu_fd_sc_mcu9t5v0__fill_1_73__VNW
+ gf180mcu_fd_sc_mcu9t5v0__fill_1_73__VPW VSS gf180mcu_fd_sc_mcu9t5v0__fill_1
* cell instance gf180mcu_fd_sc_mcu9t5v0__fill_1_74 r0 *1 0,0
Xgf180mcu_fd_sc_mcu9t5v0__fill_1_74 VDD gf180mcu_fd_sc_mcu9t5v0__fill_1_74__VNW
+ gf180mcu_fd_sc_mcu9t5v0__fill_1_74__VPW VSS gf180mcu_fd_sc_mcu9t5v0__fill_1
* cell instance gf180mcu_fd_sc_mcu9t5v0__fill_1_75 r0 *1 0,0
Xgf180mcu_fd_sc_mcu9t5v0__fill_1_75 VDD gf180mcu_fd_sc_mcu9t5v0__fill_1_75__VNW
+ gf180mcu_fd_sc_mcu9t5v0__fill_1_75__VPW VSS gf180mcu_fd_sc_mcu9t5v0__fill_1
* cell instance gf180mcu_fd_sc_mcu9t5v0__fill_1_76 r0 *1 0,0
Xgf180mcu_fd_sc_mcu9t5v0__fill_1_76 VDD gf180mcu_fd_sc_mcu9t5v0__fill_1_76__VNW
+ gf180mcu_fd_sc_mcu9t5v0__fill_1_76__VPW VSS gf180mcu_fd_sc_mcu9t5v0__fill_1
* cell instance gf180mcu_fd_sc_mcu9t5v0__fill_1_77 r0 *1 0,0
Xgf180mcu_fd_sc_mcu9t5v0__fill_1_77 VDD gf180mcu_fd_sc_mcu9t5v0__fill_1_77__VNW
+ gf180mcu_fd_sc_mcu9t5v0__fill_1_77__VPW VSS gf180mcu_fd_sc_mcu9t5v0__fill_1
* cell instance gf180mcu_fd_sc_mcu9t5v0__fill_1_78 r0 *1 0,0
Xgf180mcu_fd_sc_mcu9t5v0__fill_1_78 VDD gf180mcu_fd_sc_mcu9t5v0__fill_1_78__VNW
+ gf180mcu_fd_sc_mcu9t5v0__fill_1_78__VPW VSS gf180mcu_fd_sc_mcu9t5v0__fill_1
* cell instance gf180mcu_fd_sc_mcu9t5v0__fill_1_79 r0 *1 0,0
Xgf180mcu_fd_sc_mcu9t5v0__fill_1_79 VDD gf180mcu_fd_sc_mcu9t5v0__fill_1_79__VNW
+ gf180mcu_fd_sc_mcu9t5v0__fill_1_79__VPW VSS gf180mcu_fd_sc_mcu9t5v0__fill_1
* cell instance gf180mcu_fd_sc_mcu9t5v0__fill_1_80 r0 *1 0,0
Xgf180mcu_fd_sc_mcu9t5v0__fill_1_80 VDD gf180mcu_fd_sc_mcu9t5v0__fill_1_80__VNW
+ gf180mcu_fd_sc_mcu9t5v0__fill_1_80__VPW VSS gf180mcu_fd_sc_mcu9t5v0__fill_1
* cell instance gf180mcu_fd_sc_mcu9t5v0__fill_1_81 r0 *1 0,0
Xgf180mcu_fd_sc_mcu9t5v0__fill_1_81 VDD gf180mcu_fd_sc_mcu9t5v0__fill_1_81__VNW
+ VDD VSS gf180mcu_fd_sc_mcu9t5v0__fill_1
* cell instance gf180mcu_fd_sc_mcu9t5v0__fill_1_82 r0 *1 0,0
Xgf180mcu_fd_sc_mcu9t5v0__fill_1_82 VDD gf180mcu_fd_sc_mcu9t5v0__fill_1_82__VNW
+ gf180mcu_fd_sc_mcu9t5v0__fill_1_82__VPW VSS gf180mcu_fd_sc_mcu9t5v0__fill_1
* cell instance gf180mcu_fd_sc_mcu9t5v0__fill_1_83 r0 *1 0,0
Xgf180mcu_fd_sc_mcu9t5v0__fill_1_83 VDD gf180mcu_fd_sc_mcu9t5v0__fill_1_83__VNW
+ gf180mcu_fd_sc_mcu9t5v0__fill_1_83__VPW VSS gf180mcu_fd_sc_mcu9t5v0__fill_1
* cell instance gf180mcu_fd_sc_mcu9t5v0__fill_1_84 r0 *1 0,0
Xgf180mcu_fd_sc_mcu9t5v0__fill_1_84 VDD gf180mcu_fd_sc_mcu9t5v0__fill_1_84__VNW
+ gf180mcu_fd_sc_mcu9t5v0__fill_1_84__VPW VSS gf180mcu_fd_sc_mcu9t5v0__fill_1
* cell instance gf180mcu_fd_sc_mcu9t5v0__fill_1_85 r0 *1 0,0
Xgf180mcu_fd_sc_mcu9t5v0__fill_1_85 VDD VSS
+ gf180mcu_fd_sc_mcu9t5v0__fill_1_85__VPW VSS gf180mcu_fd_sc_mcu9t5v0__fill_1
* cell instance gf180mcu_fd_sc_mcu9t5v0__fill_1_86 r0 *1 0,0
Xgf180mcu_fd_sc_mcu9t5v0__fill_1_86 VDD gf180mcu_fd_sc_mcu9t5v0__fill_1_86__VNW
+ gf180mcu_fd_sc_mcu9t5v0__fill_1_86__VPW VSS gf180mcu_fd_sc_mcu9t5v0__fill_1
* cell instance gf180mcu_fd_sc_mcu9t5v0__fill_1_87 r0 *1 0,0
Xgf180mcu_fd_sc_mcu9t5v0__fill_1_87 VDD byte_reg[7]
+ gf180mcu_fd_sc_mcu9t5v0__fill_1_87__VPW VSS gf180mcu_fd_sc_mcu9t5v0__fill_1
* cell instance gf180mcu_fd_sc_mcu9t5v0__fill_1_88 r0 *1 0,0
Xgf180mcu_fd_sc_mcu9t5v0__fill_1_88 VDD gf180mcu_fd_sc_mcu9t5v0__fill_1_88__VNW
+ gf180mcu_fd_sc_mcu9t5v0__fill_1_88__VPW VSS gf180mcu_fd_sc_mcu9t5v0__fill_1
* cell instance gf180mcu_fd_sc_mcu9t5v0__fill_1_89 r0 *1 0,0
Xgf180mcu_fd_sc_mcu9t5v0__fill_1_89 VDD VSS
+ gf180mcu_fd_sc_mcu9t5v0__fill_1_89__VPW VSS gf180mcu_fd_sc_mcu9t5v0__fill_1
* cell instance gf180mcu_fd_sc_mcu9t5v0__fill_1_90 r0 *1 0,0
Xgf180mcu_fd_sc_mcu9t5v0__fill_1_90 VDD gf180mcu_fd_sc_mcu9t5v0__fill_1_90__VNW
+ gf180mcu_fd_sc_mcu9t5v0__fill_1_90__VPW VSS gf180mcu_fd_sc_mcu9t5v0__fill_1
* cell instance gf180mcu_fd_sc_mcu9t5v0__fill_1_91 r0 *1 0,0
Xgf180mcu_fd_sc_mcu9t5v0__fill_1_91 VDD VSS
+ gf180mcu_fd_sc_mcu9t5v0__fill_1_91__VPW VSS gf180mcu_fd_sc_mcu9t5v0__fill_1
* cell instance gf180mcu_fd_sc_mcu9t5v0__fill_1_92 r0 *1 0,0
Xgf180mcu_fd_sc_mcu9t5v0__fill_1_92 VDD gf180mcu_fd_sc_mcu9t5v0__fill_1_92__VNW
+ gf180mcu_fd_sc_mcu9t5v0__fill_1_92__VPW VSS gf180mcu_fd_sc_mcu9t5v0__fill_1
* cell instance gf180mcu_fd_sc_mcu9t5v0__fill_1_93 r0 *1 0,0
Xgf180mcu_fd_sc_mcu9t5v0__fill_1_93 VDD gf180mcu_fd_sc_mcu9t5v0__fill_1_93__VNW
+ gf180mcu_fd_sc_mcu9t5v0__fill_1_93__VPW VSS gf180mcu_fd_sc_mcu9t5v0__fill_1
* cell instance gf180mcu_fd_sc_mcu9t5v0__fill_1_94 r0 *1 0,0
Xgf180mcu_fd_sc_mcu9t5v0__fill_1_94 VDD gf180mcu_fd_sc_mcu9t5v0__fill_1_94__VNW
+ gf180mcu_fd_sc_mcu9t5v0__fill_1_94__VPW VSS gf180mcu_fd_sc_mcu9t5v0__fill_1
* cell instance gf180mcu_fd_sc_mcu9t5v0__fill_1_95 r0 *1 0,0
Xgf180mcu_fd_sc_mcu9t5v0__fill_1_95 VDD VSS VSS VSS
+ gf180mcu_fd_sc_mcu9t5v0__fill_1
* cell instance gf180mcu_fd_sc_mcu9t5v0__fill_1_96 r0 *1 0,0
Xgf180mcu_fd_sc_mcu9t5v0__fill_1_96 VDD VSS VSS VSS
+ gf180mcu_fd_sc_mcu9t5v0__fill_1
* cell instance gf180mcu_fd_sc_mcu9t5v0__fill_1_97 r0 *1 0,0
Xgf180mcu_fd_sc_mcu9t5v0__fill_1_97 VDD VSS VSS VSS
+ gf180mcu_fd_sc_mcu9t5v0__fill_1
* cell instance gf180mcu_fd_sc_mcu9t5v0__fill_1_98 r0 *1 0,0
Xgf180mcu_fd_sc_mcu9t5v0__fill_1_98 VDD VSS VSS VSS
+ gf180mcu_fd_sc_mcu9t5v0__fill_1
* cell instance gf180mcu_fd_sc_mcu9t5v0__fill_1_99 r0 *1 0,0
Xgf180mcu_fd_sc_mcu9t5v0__fill_1_99 VDD VSS VSS VSS
+ gf180mcu_fd_sc_mcu9t5v0__fill_1
* cell instance gf180mcu_fd_sc_mcu9t5v0__fill_1_100 r0 *1 0,0
Xgf180mcu_fd_sc_mcu9t5v0__fill_1_100 VDD VSS VSS VSS
+ gf180mcu_fd_sc_mcu9t5v0__fill_1
* cell instance gf180mcu_fd_sc_mcu9t5v0__fill_1_101 r0 *1 0,0
Xgf180mcu_fd_sc_mcu9t5v0__fill_1_101 VDD VSS VSS VSS
+ gf180mcu_fd_sc_mcu9t5v0__fill_1
* cell instance gf180mcu_fd_sc_mcu9t5v0__fill_1_102 r0 *1 0,0
Xgf180mcu_fd_sc_mcu9t5v0__fill_1_102 VDD VSS VSS VSS
+ gf180mcu_fd_sc_mcu9t5v0__fill_1
* cell instance gf180mcu_fd_sc_mcu9t5v0__fill_1_103 r0 *1 0,0
Xgf180mcu_fd_sc_mcu9t5v0__fill_1_103 VDD VDD VDD VSS
+ gf180mcu_fd_sc_mcu9t5v0__fill_1
* cell instance gf180mcu_fd_sc_mcu9t5v0__fill_1_104 r0 *1 0,0
Xgf180mcu_fd_sc_mcu9t5v0__fill_1_104 VDD VDD VDD VSS
+ gf180mcu_fd_sc_mcu9t5v0__fill_1
* cell instance gf180mcu_fd_sc_mcu9t5v0__fill_1_105 r0 *1 0,0
Xgf180mcu_fd_sc_mcu9t5v0__fill_1_105 VDD VDD VDD VSS
+ gf180mcu_fd_sc_mcu9t5v0__fill_1
* cell instance gf180mcu_fd_sc_mcu9t5v0__fill_1_106 r0 *1 0,0
Xgf180mcu_fd_sc_mcu9t5v0__fill_1_106 VDD VDD VDD VSS
+ gf180mcu_fd_sc_mcu9t5v0__fill_1
* cell instance gf180mcu_fd_sc_mcu9t5v0__fill_1_107 r0 *1 0,0
Xgf180mcu_fd_sc_mcu9t5v0__fill_1_107 VDD
+ gf180mcu_fd_sc_mcu9t5v0__fill_1_107__VNW
+ gf180mcu_fd_sc_mcu9t5v0__fill_1_107__VPW VSS gf180mcu_fd_sc_mcu9t5v0__fill_1
* cell instance gf180mcu_fd_sc_mcu9t5v0__fill_1_108 r0 *1 0,0
Xgf180mcu_fd_sc_mcu9t5v0__fill_1_108 VDD
+ gf180mcu_fd_sc_mcu9t5v0__fill_1_108__VNW
+ gf180mcu_fd_sc_mcu9t5v0__fill_1_108__VPW VSS gf180mcu_fd_sc_mcu9t5v0__fill_1
* cell instance gf180mcu_fd_sc_mcu9t5v0__fill_1_109 r0 *1 0,0
Xgf180mcu_fd_sc_mcu9t5v0__fill_1_109 VDD
+ gf180mcu_fd_sc_mcu9t5v0__fill_1_109__VNW
+ gf180mcu_fd_sc_mcu9t5v0__fill_1_109__VPW VSS gf180mcu_fd_sc_mcu9t5v0__fill_1
* cell instance gf180mcu_fd_sc_mcu9t5v0__fill_1_110 r0 *1 0,0
Xgf180mcu_fd_sc_mcu9t5v0__fill_1_110 VDD
+ gf180mcu_fd_sc_mcu9t5v0__fill_1_110__VNW
+ gf180mcu_fd_sc_mcu9t5v0__fill_1_110__VPW VSS gf180mcu_fd_sc_mcu9t5v0__fill_1
* cell instance gf180mcu_fd_sc_mcu9t5v0__fill_1_111 r0 *1 0,0
Xgf180mcu_fd_sc_mcu9t5v0__fill_1_111 VDD
+ gf180mcu_fd_sc_mcu9t5v0__fill_1_111__VNW
+ gf180mcu_fd_sc_mcu9t5v0__fill_1_111__VPW VSS gf180mcu_fd_sc_mcu9t5v0__fill_1
* cell instance gf180mcu_fd_sc_mcu9t5v0__fill_1_112 r0 *1 0,0
Xgf180mcu_fd_sc_mcu9t5v0__fill_1_112 VDD
+ gf180mcu_fd_sc_mcu9t5v0__fill_1_112__VNW
+ gf180mcu_fd_sc_mcu9t5v0__fill_1_112__VPW VSS gf180mcu_fd_sc_mcu9t5v0__fill_1
* cell instance gf180mcu_fd_sc_mcu9t5v0__fill_1_113 r0 *1 0,0
Xgf180mcu_fd_sc_mcu9t5v0__fill_1_113 VDD byte_idx[2]
+ gf180mcu_fd_sc_mcu9t5v0__fill_1_113__VPW VSS gf180mcu_fd_sc_mcu9t5v0__fill_1
* cell instance gf180mcu_fd_sc_mcu9t5v0__fill_1_114 r0 *1 0,0
Xgf180mcu_fd_sc_mcu9t5v0__fill_1_114 VDD
+ gf180mcu_fd_sc_mcu9t5v0__fill_1_114__VNW
+ gf180mcu_fd_sc_mcu9t5v0__fill_1_114__VPW VSS gf180mcu_fd_sc_mcu9t5v0__fill_1
* cell instance gf180mcu_fd_sc_mcu9t5v0__fill_1_115 r0 *1 0,0
Xgf180mcu_fd_sc_mcu9t5v0__fill_1_115 VDD
+ gf180mcu_fd_sc_mcu9t5v0__fill_1_115__VNW VDD VSS
+ gf180mcu_fd_sc_mcu9t5v0__fill_1
* cell instance gf180mcu_fd_sc_mcu9t5v0__fill_1_116 r0 *1 0,0
Xgf180mcu_fd_sc_mcu9t5v0__fill_1_116 VDD
+ gf180mcu_fd_sc_mcu9t5v0__fill_1_116__VNW
+ gf180mcu_fd_sc_mcu9t5v0__fill_1_116__VPW VSS gf180mcu_fd_sc_mcu9t5v0__fill_1
* cell instance gf180mcu_fd_sc_mcu9t5v0__fill_1_117 r0 *1 0,0
Xgf180mcu_fd_sc_mcu9t5v0__fill_1_117 VDD \_072_
+ gf180mcu_fd_sc_mcu9t5v0__fill_1_117__VPW VSS gf180mcu_fd_sc_mcu9t5v0__fill_1
* cell instance gf180mcu_fd_sc_mcu9t5v0__fill_1_118 r0 *1 0,0
Xgf180mcu_fd_sc_mcu9t5v0__fill_1_118 VDD
+ gf180mcu_fd_sc_mcu9t5v0__fill_1_118__VNW
+ gf180mcu_fd_sc_mcu9t5v0__fill_1_118__VPW VSS gf180mcu_fd_sc_mcu9t5v0__fill_1
* cell instance gf180mcu_fd_sc_mcu9t5v0__fill_1_119 r0 *1 0,0
Xgf180mcu_fd_sc_mcu9t5v0__fill_1_119 VDD VSS
+ gf180mcu_fd_sc_mcu9t5v0__fill_1_119__VPW VSS gf180mcu_fd_sc_mcu9t5v0__fill_1
* cell instance gf180mcu_fd_sc_mcu9t5v0__fill_1_120 r0 *1 0,0
Xgf180mcu_fd_sc_mcu9t5v0__fill_1_120 VDD
+ gf180mcu_fd_sc_mcu9t5v0__fill_1_120__VNW
+ gf180mcu_fd_sc_mcu9t5v0__fill_1_120__VPW VSS gf180mcu_fd_sc_mcu9t5v0__fill_1
* cell instance gf180mcu_fd_sc_mcu9t5v0__fill_1_121 r0 *1 0,0
Xgf180mcu_fd_sc_mcu9t5v0__fill_1_121 VDD
+ gf180mcu_fd_sc_mcu9t5v0__fill_1_121__VNW
+ gf180mcu_fd_sc_mcu9t5v0__fill_1_121__VPW VSS gf180mcu_fd_sc_mcu9t5v0__fill_1
* cell instance gf180mcu_fd_sc_mcu9t5v0__fill_1_122 r0 *1 0,0
Xgf180mcu_fd_sc_mcu9t5v0__fill_1_122 VDD
+ gf180mcu_fd_sc_mcu9t5v0__fill_1_122__VNW
+ gf180mcu_fd_sc_mcu9t5v0__fill_1_122__VPW VSS gf180mcu_fd_sc_mcu9t5v0__fill_1
* cell instance gf180mcu_fd_sc_mcu9t5v0__fill_1_123 r0 *1 0,0
Xgf180mcu_fd_sc_mcu9t5v0__fill_1_123 VDD
+ gf180mcu_fd_sc_mcu9t5v0__fill_1_123__VNW
+ gf180mcu_fd_sc_mcu9t5v0__fill_1_123__VPW VSS gf180mcu_fd_sc_mcu9t5v0__fill_1
* cell instance gf180mcu_fd_sc_mcu9t5v0__fill_1_124 r0 *1 0,0
Xgf180mcu_fd_sc_mcu9t5v0__fill_1_124 VDD
+ gf180mcu_fd_sc_mcu9t5v0__fill_1_124__VNW
+ gf180mcu_fd_sc_mcu9t5v0__fill_1_124__VPW VSS gf180mcu_fd_sc_mcu9t5v0__fill_1
* cell instance gf180mcu_fd_sc_mcu9t5v0__fill_1_125 r0 *1 0,0
Xgf180mcu_fd_sc_mcu9t5v0__fill_1_125 VDD VSS
+ gf180mcu_fd_sc_mcu9t5v0__fill_1_125__VPW VSS gf180mcu_fd_sc_mcu9t5v0__fill_1
* cell instance gf180mcu_fd_sc_mcu9t5v0__fill_1_126 r0 *1 0,0
Xgf180mcu_fd_sc_mcu9t5v0__fill_1_126 VDD \_077_
+ gf180mcu_fd_sc_mcu9t5v0__fill_1_126__VPW VSS gf180mcu_fd_sc_mcu9t5v0__fill_1
* cell instance gf180mcu_fd_sc_mcu9t5v0__fill_1_127 r0 *1 0,0
Xgf180mcu_fd_sc_mcu9t5v0__fill_1_127 VDD
+ gf180mcu_fd_sc_mcu9t5v0__fill_1_127__VNW
+ gf180mcu_fd_sc_mcu9t5v0__fill_1_127__VPW VSS gf180mcu_fd_sc_mcu9t5v0__fill_1
* cell instance gf180mcu_fd_sc_mcu9t5v0__fill_1_128 r0 *1 0,0
Xgf180mcu_fd_sc_mcu9t5v0__fill_1_128 VDD
+ gf180mcu_fd_sc_mcu9t5v0__fill_1_128__VNW
+ gf180mcu_fd_sc_mcu9t5v0__fill_1_128__VPW VSS gf180mcu_fd_sc_mcu9t5v0__fill_1
* cell instance gf180mcu_fd_sc_mcu9t5v0__fill_1_129 r0 *1 0,0
Xgf180mcu_fd_sc_mcu9t5v0__fill_1_129 VDD tx_state[2]
+ gf180mcu_fd_sc_mcu9t5v0__fill_1_129__VPW VSS gf180mcu_fd_sc_mcu9t5v0__fill_1
* cell instance gf180mcu_fd_sc_mcu9t5v0__fill_1_130 r0 *1 0,0
Xgf180mcu_fd_sc_mcu9t5v0__fill_1_130 VDD VSS
+ gf180mcu_fd_sc_mcu9t5v0__fill_1_130__VPW VSS gf180mcu_fd_sc_mcu9t5v0__fill_1
* cell instance gf180mcu_fd_sc_mcu9t5v0__fill_1_131 r0 *1 0,0
Xgf180mcu_fd_sc_mcu9t5v0__fill_1_131 VDD
+ gf180mcu_fd_sc_mcu9t5v0__fill_1_131__VNW
+ gf180mcu_fd_sc_mcu9t5v0__fill_1_131__VPW VSS gf180mcu_fd_sc_mcu9t5v0__fill_1
* cell instance gf180mcu_fd_sc_mcu9t5v0__fill_1_132 r0 *1 0,0
Xgf180mcu_fd_sc_mcu9t5v0__fill_1_132 VDD clknet_3_5__leaf_clk VSS VSS
+ gf180mcu_fd_sc_mcu9t5v0__fill_1
* cell instance gf180mcu_fd_sc_mcu9t5v0__fill_1_133 r0 *1 0,0
Xgf180mcu_fd_sc_mcu9t5v0__fill_1_133 VDD VSS VSS VSS
+ gf180mcu_fd_sc_mcu9t5v0__fill_1
* cell instance gf180mcu_fd_sc_mcu9t5v0__fill_1_134 r0 *1 0,0
Xgf180mcu_fd_sc_mcu9t5v0__fill_1_134 VDD \_064_ VSS VSS
+ gf180mcu_fd_sc_mcu9t5v0__fill_1
* cell instance gf180mcu_fd_sc_mcu9t5v0__fill_1_135 r0 *1 0,0
Xgf180mcu_fd_sc_mcu9t5v0__fill_1_135 VDD VSS VSS VSS
+ gf180mcu_fd_sc_mcu9t5v0__fill_1
* cell instance gf180mcu_fd_sc_mcu9t5v0__fill_1_136 r0 *1 0,0
Xgf180mcu_fd_sc_mcu9t5v0__fill_1_136 VDD VSS VSS VSS
+ gf180mcu_fd_sc_mcu9t5v0__fill_1
* cell instance gf180mcu_fd_sc_mcu9t5v0__fill_1_137 r0 *1 0,0
Xgf180mcu_fd_sc_mcu9t5v0__fill_1_137 VDD VSS VSS VSS
+ gf180mcu_fd_sc_mcu9t5v0__fill_1
* cell instance gf180mcu_fd_sc_mcu9t5v0__fill_1_138 r0 *1 0,0
Xgf180mcu_fd_sc_mcu9t5v0__fill_1_138 VDD byte_idx[2] VSS VSS
+ gf180mcu_fd_sc_mcu9t5v0__fill_1
* cell instance gf180mcu_fd_sc_mcu9t5v0__fill_1_139 r0 *1 0,0
Xgf180mcu_fd_sc_mcu9t5v0__fill_1_139 VDD VSS VSS VSS
+ gf180mcu_fd_sc_mcu9t5v0__fill_1
* cell instance gf180mcu_fd_sc_mcu9t5v0__fill_1_140 r0 *1 0,0
Xgf180mcu_fd_sc_mcu9t5v0__fill_1_140 VDD VSS VSS VSS
+ gf180mcu_fd_sc_mcu9t5v0__fill_1
* cell instance gf180mcu_fd_sc_mcu9t5v0__fill_1_141 r0 *1 0,0
Xgf180mcu_fd_sc_mcu9t5v0__fill_1_141 VDD VDD VDD VSS
+ gf180mcu_fd_sc_mcu9t5v0__fill_1
* cell instance gf180mcu_fd_sc_mcu9t5v0__fill_1_142 r0 *1 0,0
Xgf180mcu_fd_sc_mcu9t5v0__fill_1_142 VDD VDD VDD VSS
+ gf180mcu_fd_sc_mcu9t5v0__fill_1
* cell instance gf180mcu_fd_sc_mcu9t5v0__fill_1_143 r0 *1 0,0
Xgf180mcu_fd_sc_mcu9t5v0__fill_1_143 VDD \_064_ VDD VSS
+ gf180mcu_fd_sc_mcu9t5v0__fill_1
* cell instance gf180mcu_fd_sc_mcu9t5v0__fill_1_144 r0 *1 0,0
Xgf180mcu_fd_sc_mcu9t5v0__fill_1_144 VDD
+ gf180mcu_fd_sc_mcu9t5v0__fill_1_144__VNW
+ gf180mcu_fd_sc_mcu9t5v0__fill_1_144__VPW VSS gf180mcu_fd_sc_mcu9t5v0__fill_1
* cell instance gf180mcu_fd_sc_mcu9t5v0__fill_1_145 r0 *1 0,0
Xgf180mcu_fd_sc_mcu9t5v0__fill_1_145 VDD
+ gf180mcu_fd_sc_mcu9t5v0__fill_1_145__VNW
+ gf180mcu_fd_sc_mcu9t5v0__fill_1_145__VPW VSS gf180mcu_fd_sc_mcu9t5v0__fill_1
* cell instance gf180mcu_fd_sc_mcu9t5v0__fill_1_146 r0 *1 0,0
Xgf180mcu_fd_sc_mcu9t5v0__fill_1_146 VDD
+ gf180mcu_fd_sc_mcu9t5v0__fill_1_146__VNW
+ gf180mcu_fd_sc_mcu9t5v0__fill_1_146__VPW VSS gf180mcu_fd_sc_mcu9t5v0__fill_1
* cell instance gf180mcu_fd_sc_mcu9t5v0__fill_1_147 r0 *1 0,0
Xgf180mcu_fd_sc_mcu9t5v0__fill_1_147 VDD
+ gf180mcu_fd_sc_mcu9t5v0__fill_1_147__VNW
+ gf180mcu_fd_sc_mcu9t5v0__fill_1_147__VPW VSS gf180mcu_fd_sc_mcu9t5v0__fill_1
* cell instance gf180mcu_fd_sc_mcu9t5v0__fill_1_148 r0 *1 0,0
Xgf180mcu_fd_sc_mcu9t5v0__fill_1_148 VDD
+ gf180mcu_fd_sc_mcu9t5v0__fill_1_148__VNW
+ gf180mcu_fd_sc_mcu9t5v0__fill_1_148__VPW VSS gf180mcu_fd_sc_mcu9t5v0__fill_1
* cell instance gf180mcu_fd_sc_mcu9t5v0__fill_1_149 r0 *1 0,0
Xgf180mcu_fd_sc_mcu9t5v0__fill_1_149 VDD
+ gf180mcu_fd_sc_mcu9t5v0__fill_1_149__VNW
+ gf180mcu_fd_sc_mcu9t5v0__fill_1_149__VPW VSS gf180mcu_fd_sc_mcu9t5v0__fill_1
* cell instance gf180mcu_fd_sc_mcu9t5v0__fill_1_150 r0 *1 0,0
Xgf180mcu_fd_sc_mcu9t5v0__fill_1_150 VDD
+ gf180mcu_fd_sc_mcu9t5v0__fill_1_150__VNW
+ gf180mcu_fd_sc_mcu9t5v0__fill_1_150__VPW VSS gf180mcu_fd_sc_mcu9t5v0__fill_1
* cell instance gf180mcu_fd_sc_mcu9t5v0__fill_1_151 r0 *1 0,0
Xgf180mcu_fd_sc_mcu9t5v0__fill_1_151 VDD
+ gf180mcu_fd_sc_mcu9t5v0__fill_1_151__VNW
+ gf180mcu_fd_sc_mcu9t5v0__fill_1_151__VPW VSS gf180mcu_fd_sc_mcu9t5v0__fill_1
* cell instance gf180mcu_fd_sc_mcu9t5v0__fill_1_152 r0 *1 0,0
Xgf180mcu_fd_sc_mcu9t5v0__fill_1_152 VDD
+ gf180mcu_fd_sc_mcu9t5v0__fill_1_152__VNW
+ gf180mcu_fd_sc_mcu9t5v0__fill_1_152__VPW VSS gf180mcu_fd_sc_mcu9t5v0__fill_1
* cell instance gf180mcu_fd_sc_mcu9t5v0__fill_1_153 r0 *1 0,0
Xgf180mcu_fd_sc_mcu9t5v0__fill_1_153 VDD
+ gf180mcu_fd_sc_mcu9t5v0__fill_1_153__VNW
+ gf180mcu_fd_sc_mcu9t5v0__fill_1_153__VPW VSS gf180mcu_fd_sc_mcu9t5v0__fill_1
* cell instance gf180mcu_fd_sc_mcu9t5v0__fill_1_154 r0 *1 0,0
Xgf180mcu_fd_sc_mcu9t5v0__fill_1_154 VDD
+ gf180mcu_fd_sc_mcu9t5v0__fill_1_154__VNW
+ gf180mcu_fd_sc_mcu9t5v0__fill_1_154__VPW VSS gf180mcu_fd_sc_mcu9t5v0__fill_1
* cell instance gf180mcu_fd_sc_mcu9t5v0__fill_1_155 r0 *1 0,0
Xgf180mcu_fd_sc_mcu9t5v0__fill_1_155 VDD
+ gf180mcu_fd_sc_mcu9t5v0__fill_1_155__VNW VDD VSS
+ gf180mcu_fd_sc_mcu9t5v0__fill_1
* cell instance gf180mcu_fd_sc_mcu9t5v0__fill_1_156 r0 *1 0,0
Xgf180mcu_fd_sc_mcu9t5v0__fill_1_156 VDD
+ gf180mcu_fd_sc_mcu9t5v0__fill_1_156__VNW
+ gf180mcu_fd_sc_mcu9t5v0__fill_1_156__VPW VSS gf180mcu_fd_sc_mcu9t5v0__fill_1
* cell instance gf180mcu_fd_sc_mcu9t5v0__fill_1_157 r0 *1 0,0
Xgf180mcu_fd_sc_mcu9t5v0__fill_1_157 VDD
+ gf180mcu_fd_sc_mcu9t5v0__fill_1_157__VNW
+ gf180mcu_fd_sc_mcu9t5v0__fill_1_157__VPW VSS gf180mcu_fd_sc_mcu9t5v0__fill_1
* cell instance gf180mcu_fd_sc_mcu9t5v0__fill_1_158 r0 *1 0,0
Xgf180mcu_fd_sc_mcu9t5v0__fill_1_158 VDD
+ gf180mcu_fd_sc_mcu9t5v0__fill_1_158__VNW
+ gf180mcu_fd_sc_mcu9t5v0__fill_1_158__VPW VSS gf180mcu_fd_sc_mcu9t5v0__fill_1
* cell instance gf180mcu_fd_sc_mcu9t5v0__fill_1_159 r0 *1 0,0
Xgf180mcu_fd_sc_mcu9t5v0__fill_1_159 VDD VSS
+ gf180mcu_fd_sc_mcu9t5v0__fill_1_159__VPW VSS gf180mcu_fd_sc_mcu9t5v0__fill_1
* cell instance gf180mcu_fd_sc_mcu9t5v0__fill_1_160 r0 *1 0,0
Xgf180mcu_fd_sc_mcu9t5v0__fill_1_160 VDD
+ gf180mcu_fd_sc_mcu9t5v0__fill_1_160__VNW
+ gf180mcu_fd_sc_mcu9t5v0__fill_1_160__VPW VSS gf180mcu_fd_sc_mcu9t5v0__fill_1
* cell instance gf180mcu_fd_sc_mcu9t5v0__fill_16_0 r0 *1 0,0
Xgf180mcu_fd_sc_mcu9t5v0__fill_16_0 VDD clknet_3_0__leaf_clk
+ gf180mcu_fd_sc_mcu9t5v0__fill_16_0__VPW VSS gf180mcu_fd_sc_mcu9t5v0__fill_16
* cell instance gf180mcu_fd_sc_mcu9t5v0__fill_16_1 r0 *1 0,0
Xgf180mcu_fd_sc_mcu9t5v0__fill_16_1 VDD gf180mcu_fd_sc_mcu9t5v0__fill_16_1__VNW
+ gf180mcu_fd_sc_mcu9t5v0__fill_16_1__VPW VSS gf180mcu_fd_sc_mcu9t5v0__fill_16
* cell instance gf180mcu_fd_sc_mcu9t5v0__fill_16_2 r0 *1 0,0
Xgf180mcu_fd_sc_mcu9t5v0__fill_16_2 VDD gf180mcu_fd_sc_mcu9t5v0__fill_16_2__VNW
+ gf180mcu_fd_sc_mcu9t5v0__fill_16_2__VPW VSS gf180mcu_fd_sc_mcu9t5v0__fill_16
* cell instance gf180mcu_fd_sc_mcu9t5v0__fill_16_3 r0 *1 0,0
Xgf180mcu_fd_sc_mcu9t5v0__fill_16_3 VDD gf180mcu_fd_sc_mcu9t5v0__fill_16_3__VNW
+ gf180mcu_fd_sc_mcu9t5v0__fill_16_3__VPW VSS gf180mcu_fd_sc_mcu9t5v0__fill_16
* cell instance gf180mcu_fd_sc_mcu9t5v0__fill_16_4 r0 *1 0,0
Xgf180mcu_fd_sc_mcu9t5v0__fill_16_4 VDD VSS VSS VSS
+ gf180mcu_fd_sc_mcu9t5v0__fill_16
* cell instance gf180mcu_fd_sc_mcu9t5v0__fill_16_5 r0 *1 0,0
Xgf180mcu_fd_sc_mcu9t5v0__fill_16_5 VDD VSS VSS VSS
+ gf180mcu_fd_sc_mcu9t5v0__fill_16
* cell instance gf180mcu_fd_sc_mcu9t5v0__fill_16_6 r0 *1 0,0
Xgf180mcu_fd_sc_mcu9t5v0__fill_16_6 VDD VSS VSS VSS
+ gf180mcu_fd_sc_mcu9t5v0__fill_16
* cell instance gf180mcu_fd_sc_mcu9t5v0__fill_16_7 r0 *1 0,0
Xgf180mcu_fd_sc_mcu9t5v0__fill_16_7 VDD VSS VSS VSS
+ gf180mcu_fd_sc_mcu9t5v0__fill_16
* cell instance gf180mcu_fd_sc_mcu9t5v0__fill_16_8 r0 *1 0,0
Xgf180mcu_fd_sc_mcu9t5v0__fill_16_8 VDD VSS VSS VSS
+ gf180mcu_fd_sc_mcu9t5v0__fill_16
* cell instance gf180mcu_fd_sc_mcu9t5v0__fill_16_9 r0 *1 0,0
Xgf180mcu_fd_sc_mcu9t5v0__fill_16_9 VDD VSS VSS VSS
+ gf180mcu_fd_sc_mcu9t5v0__fill_16
* cell instance gf180mcu_fd_sc_mcu9t5v0__fill_16_10 r0 *1 0,0
Xgf180mcu_fd_sc_mcu9t5v0__fill_16_10 VDD VSS VSS VSS
+ gf180mcu_fd_sc_mcu9t5v0__fill_16
* cell instance gf180mcu_fd_sc_mcu9t5v0__fill_16_11 r0 *1 0,0
Xgf180mcu_fd_sc_mcu9t5v0__fill_16_11 VDD VSS VSS VSS
+ gf180mcu_fd_sc_mcu9t5v0__fill_16
* cell instance gf180mcu_fd_sc_mcu9t5v0__fill_16_12 r0 *1 0,0
Xgf180mcu_fd_sc_mcu9t5v0__fill_16_12 VDD VSS VSS VSS
+ gf180mcu_fd_sc_mcu9t5v0__fill_16
* cell instance gf180mcu_fd_sc_mcu9t5v0__fill_16_13 r0 *1 0,0
Xgf180mcu_fd_sc_mcu9t5v0__fill_16_13 VDD VSS VSS VSS
+ gf180mcu_fd_sc_mcu9t5v0__fill_16
* cell instance gf180mcu_fd_sc_mcu9t5v0__fill_16_14 r0 *1 0,0
Xgf180mcu_fd_sc_mcu9t5v0__fill_16_14 VDD VSS VSS VSS
+ gf180mcu_fd_sc_mcu9t5v0__fill_16
* cell instance gf180mcu_fd_sc_mcu9t5v0__fill_16_15 r0 *1 0,0
Xgf180mcu_fd_sc_mcu9t5v0__fill_16_15 VDD
+ gf180mcu_fd_sc_mcu9t5v0__fill_16_15__VNW
+ gf180mcu_fd_sc_mcu9t5v0__fill_16_15__VPW VSS gf180mcu_fd_sc_mcu9t5v0__fill_16
* cell instance gf180mcu_fd_sc_mcu9t5v0__fill_16_16 r0 *1 0,0
Xgf180mcu_fd_sc_mcu9t5v0__fill_16_16 VDD
+ gf180mcu_fd_sc_mcu9t5v0__fill_16_16__VNW
+ gf180mcu_fd_sc_mcu9t5v0__fill_16_16__VPW VSS gf180mcu_fd_sc_mcu9t5v0__fill_16
* cell instance gf180mcu_fd_sc_mcu9t5v0__fill_16_17 r0 *1 0,0
Xgf180mcu_fd_sc_mcu9t5v0__fill_16_17 VDD
+ gf180mcu_fd_sc_mcu9t5v0__fill_16_17__VNW
+ gf180mcu_fd_sc_mcu9t5v0__fill_16_17__VPW VSS gf180mcu_fd_sc_mcu9t5v0__fill_16
* cell instance gf180mcu_fd_sc_mcu9t5v0__fill_16_18 r0 *1 0,0
Xgf180mcu_fd_sc_mcu9t5v0__fill_16_18 VDD VSS
+ gf180mcu_fd_sc_mcu9t5v0__fill_16_18__VPW VSS gf180mcu_fd_sc_mcu9t5v0__fill_16
* cell instance gf180mcu_fd_sc_mcu9t5v0__fill_16_19 r0 *1 0,0
Xgf180mcu_fd_sc_mcu9t5v0__fill_16_19 VDD
+ gf180mcu_fd_sc_mcu9t5v0__fill_16_19__VNW
+ gf180mcu_fd_sc_mcu9t5v0__fill_16_19__VPW VSS gf180mcu_fd_sc_mcu9t5v0__fill_16
* cell instance gf180mcu_fd_sc_mcu9t5v0__fill_16_20 r0 *1 0,0
Xgf180mcu_fd_sc_mcu9t5v0__fill_16_20 VDD
+ gf180mcu_fd_sc_mcu9t5v0__fill_16_20__VNW
+ gf180mcu_fd_sc_mcu9t5v0__fill_16_20__VPW VSS gf180mcu_fd_sc_mcu9t5v0__fill_16
* cell instance gf180mcu_fd_sc_mcu9t5v0__fill_16_21 r0 *1 0,0
Xgf180mcu_fd_sc_mcu9t5v0__fill_16_21 VDD
+ gf180mcu_fd_sc_mcu9t5v0__fill_16_21__VNW
+ gf180mcu_fd_sc_mcu9t5v0__fill_16_21__VPW VSS gf180mcu_fd_sc_mcu9t5v0__fill_16
* cell instance gf180mcu_fd_sc_mcu9t5v0__fill_16_22 r0 *1 0,0
Xgf180mcu_fd_sc_mcu9t5v0__fill_16_22 VDD
+ gf180mcu_fd_sc_mcu9t5v0__fill_16_22__VNW
+ gf180mcu_fd_sc_mcu9t5v0__fill_16_22__VPW VSS gf180mcu_fd_sc_mcu9t5v0__fill_16
* cell instance gf180mcu_fd_sc_mcu9t5v0__fill_16_23 r0 *1 0,0
Xgf180mcu_fd_sc_mcu9t5v0__fill_16_23 VDD
+ gf180mcu_fd_sc_mcu9t5v0__fill_16_23__VNW
+ gf180mcu_fd_sc_mcu9t5v0__fill_16_23__VPW VSS gf180mcu_fd_sc_mcu9t5v0__fill_16
* cell instance gf180mcu_fd_sc_mcu9t5v0__fill_16_24 r0 *1 0,0
Xgf180mcu_fd_sc_mcu9t5v0__fill_16_24 VDD
+ gf180mcu_fd_sc_mcu9t5v0__fill_16_24__VNW
+ gf180mcu_fd_sc_mcu9t5v0__fill_16_24__VPW VSS gf180mcu_fd_sc_mcu9t5v0__fill_16
* cell instance gf180mcu_fd_sc_mcu9t5v0__fill_16_25 r0 *1 0,0
Xgf180mcu_fd_sc_mcu9t5v0__fill_16_25 VDD
+ gf180mcu_fd_sc_mcu9t5v0__fill_16_25__VNW
+ gf180mcu_fd_sc_mcu9t5v0__fill_16_25__VPW VSS gf180mcu_fd_sc_mcu9t5v0__fill_16
* cell instance gf180mcu_fd_sc_mcu9t5v0__fill_16_26 r0 *1 0,0
Xgf180mcu_fd_sc_mcu9t5v0__fill_16_26 VDD
+ gf180mcu_fd_sc_mcu9t5v0__fill_16_26__VNW
+ gf180mcu_fd_sc_mcu9t5v0__fill_16_26__VPW VSS gf180mcu_fd_sc_mcu9t5v0__fill_16
* cell instance gf180mcu_fd_sc_mcu9t5v0__fill_16_27 r0 *1 0,0
Xgf180mcu_fd_sc_mcu9t5v0__fill_16_27 VDD
+ gf180mcu_fd_sc_mcu9t5v0__fill_16_27__VNW
+ gf180mcu_fd_sc_mcu9t5v0__fill_16_27__VPW VSS gf180mcu_fd_sc_mcu9t5v0__fill_16
* cell instance gf180mcu_fd_sc_mcu9t5v0__fill_16_28 r0 *1 0,0
Xgf180mcu_fd_sc_mcu9t5v0__fill_16_28 VDD DataIn[1] VSS VSS
+ gf180mcu_fd_sc_mcu9t5v0__fill_16
* cell instance gf180mcu_fd_sc_mcu9t5v0__fill_16_29 r0 *1 0,0
Xgf180mcu_fd_sc_mcu9t5v0__fill_16_29 VDD DataIn[0] VSS VSS
+ gf180mcu_fd_sc_mcu9t5v0__fill_16
* cell instance gf180mcu_fd_sc_mcu9t5v0__fill_16_30 r0 *1 0,0
Xgf180mcu_fd_sc_mcu9t5v0__fill_16_30 VDD VSS VSS VSS
+ gf180mcu_fd_sc_mcu9t5v0__fill_16
* cell instance gf180mcu_fd_sc_mcu9t5v0__fill_16_31 r0 *1 0,0
Xgf180mcu_fd_sc_mcu9t5v0__fill_16_31 VDD VSS VSS VSS
+ gf180mcu_fd_sc_mcu9t5v0__fill_16
* cell instance gf180mcu_fd_sc_mcu9t5v0__fill_16_32 r0 *1 0,0
Xgf180mcu_fd_sc_mcu9t5v0__fill_16_32 VDD VSS VSS VSS
+ gf180mcu_fd_sc_mcu9t5v0__fill_16
* cell instance gf180mcu_fd_sc_mcu9t5v0__fill_16_33 r0 *1 0,0
Xgf180mcu_fd_sc_mcu9t5v0__fill_16_33 VDD VDD VDD VSS
+ gf180mcu_fd_sc_mcu9t5v0__fill_16
* cell instance gf180mcu_fd_sc_mcu9t5v0__fill_16_34 r0 *1 0,0
Xgf180mcu_fd_sc_mcu9t5v0__fill_16_34 VDD
+ gf180mcu_fd_sc_mcu9t5v0__fill_16_34__VNW
+ gf180mcu_fd_sc_mcu9t5v0__fill_16_34__VPW VSS gf180mcu_fd_sc_mcu9t5v0__fill_16
* cell instance gf180mcu_fd_sc_mcu9t5v0__fill_16_35 r0 *1 0,0
Xgf180mcu_fd_sc_mcu9t5v0__fill_16_35 VDD DataIn[0]
+ gf180mcu_fd_sc_mcu9t5v0__fill_16_35__VPW VSS gf180mcu_fd_sc_mcu9t5v0__fill_16
* cell instance gf180mcu_fd_sc_mcu9t5v0__fill_16_36 r0 *1 0,0
Xgf180mcu_fd_sc_mcu9t5v0__fill_16_36 VDD
+ gf180mcu_fd_sc_mcu9t5v0__fill_16_36__VNW
+ gf180mcu_fd_sc_mcu9t5v0__fill_16_36__VPW VSS gf180mcu_fd_sc_mcu9t5v0__fill_16
* cell instance gf180mcu_fd_sc_mcu9t5v0__fill_16_37 r0 *1 0,0
Xgf180mcu_fd_sc_mcu9t5v0__fill_16_37 VDD byte_reg[7] byte_reg[7] VSS
+ gf180mcu_fd_sc_mcu9t5v0__fill_16
* cell instance gf180mcu_fd_sc_mcu9t5v0__fill_16_38 r0 *1 0,0
Xgf180mcu_fd_sc_mcu9t5v0__fill_16_38 VDD
+ gf180mcu_fd_sc_mcu9t5v0__fill_16_38__VNW
+ gf180mcu_fd_sc_mcu9t5v0__fill_16_38__VPW VSS gf180mcu_fd_sc_mcu9t5v0__fill_16
* cell instance gf180mcu_fd_sc_mcu9t5v0__fill_16_39 r0 *1 0,0
Xgf180mcu_fd_sc_mcu9t5v0__fill_16_39 VDD VSS
+ gf180mcu_fd_sc_mcu9t5v0__fill_16_39__VPW VSS gf180mcu_fd_sc_mcu9t5v0__fill_16
* cell instance gf180mcu_fd_sc_mcu9t5v0__fill_16_40 r0 *1 0,0
Xgf180mcu_fd_sc_mcu9t5v0__fill_16_40 VDD
+ gf180mcu_fd_sc_mcu9t5v0__fill_16_40__VNW
+ gf180mcu_fd_sc_mcu9t5v0__fill_16_40__VPW VSS gf180mcu_fd_sc_mcu9t5v0__fill_16
* cell instance gf180mcu_fd_sc_mcu9t5v0__fill_16_41 r0 *1 0,0
Xgf180mcu_fd_sc_mcu9t5v0__fill_16_41 VDD
+ gf180mcu_fd_sc_mcu9t5v0__fill_16_41__VNW
+ gf180mcu_fd_sc_mcu9t5v0__fill_16_41__VPW VSS gf180mcu_fd_sc_mcu9t5v0__fill_16
* cell instance gf180mcu_fd_sc_mcu9t5v0__fill_16_42 r0 *1 0,0
Xgf180mcu_fd_sc_mcu9t5v0__fill_16_42 VDD rst_n rst_n VSS
+ gf180mcu_fd_sc_mcu9t5v0__fill_16
* cell instance gf180mcu_fd_sc_mcu9t5v0__fill_16_43 r0 *1 0,0
Xgf180mcu_fd_sc_mcu9t5v0__fill_16_43 VDD
+ gf180mcu_fd_sc_mcu9t5v0__fill_16_43__VNW
+ gf180mcu_fd_sc_mcu9t5v0__fill_16_43__VPW VSS gf180mcu_fd_sc_mcu9t5v0__fill_16
* cell instance gf180mcu_fd_sc_mcu9t5v0__fill_16_44 r0 *1 0,0
Xgf180mcu_fd_sc_mcu9t5v0__fill_16_44 VDD clknet_3_6__leaf_clk
+ clknet_3_6__leaf_clk VSS gf180mcu_fd_sc_mcu9t5v0__fill_16
* cell instance gf180mcu_fd_sc_mcu9t5v0__fill_16_45 r0 *1 0,0
Xgf180mcu_fd_sc_mcu9t5v0__fill_16_45 VDD
+ gf180mcu_fd_sc_mcu9t5v0__fill_16_45__VNW
+ gf180mcu_fd_sc_mcu9t5v0__fill_16_45__VPW VSS gf180mcu_fd_sc_mcu9t5v0__fill_16
* cell instance gf180mcu_fd_sc_mcu9t5v0__fill_16_46 r0 *1 0,0
Xgf180mcu_fd_sc_mcu9t5v0__fill_16_46 VDD VSS
+ gf180mcu_fd_sc_mcu9t5v0__fill_16_46__VPW VSS gf180mcu_fd_sc_mcu9t5v0__fill_16
* cell instance gf180mcu_fd_sc_mcu9t5v0__fill_16_47 r0 *1 0,0
Xgf180mcu_fd_sc_mcu9t5v0__fill_16_47 VDD
+ gf180mcu_fd_sc_mcu9t5v0__fill_16_47__VNW
+ gf180mcu_fd_sc_mcu9t5v0__fill_16_47__VPW VSS gf180mcu_fd_sc_mcu9t5v0__fill_16
* cell instance gf180mcu_fd_sc_mcu9t5v0__fill_16_48 r0 *1 0,0
Xgf180mcu_fd_sc_mcu9t5v0__fill_16_48 VDD
+ gf180mcu_fd_sc_mcu9t5v0__fill_16_48__VNW
+ gf180mcu_fd_sc_mcu9t5v0__fill_16_48__VPW VSS gf180mcu_fd_sc_mcu9t5v0__fill_16
* cell instance gf180mcu_fd_sc_mcu9t5v0__fill_16_49 r0 *1 0,0
Xgf180mcu_fd_sc_mcu9t5v0__fill_16_49 VDD
+ gf180mcu_fd_sc_mcu9t5v0__fill_16_49__VNW
+ gf180mcu_fd_sc_mcu9t5v0__fill_16_49__VPW VSS gf180mcu_fd_sc_mcu9t5v0__fill_16
* cell instance gf180mcu_fd_sc_mcu9t5v0__fill_16_50 r0 *1 0,0
Xgf180mcu_fd_sc_mcu9t5v0__fill_16_50 VDD
+ gf180mcu_fd_sc_mcu9t5v0__fill_16_50__VNW
+ gf180mcu_fd_sc_mcu9t5v0__fill_16_50__VPW VSS gf180mcu_fd_sc_mcu9t5v0__fill_16
* cell instance gf180mcu_fd_sc_mcu9t5v0__fill_16_51 r0 *1 0,0
Xgf180mcu_fd_sc_mcu9t5v0__fill_16_51 VDD
+ gf180mcu_fd_sc_mcu9t5v0__fill_16_51__VNW VDD VSS
+ gf180mcu_fd_sc_mcu9t5v0__fill_16
* cell instance gf180mcu_fd_sc_mcu9t5v0__fill_16_52 r0 *1 0,0
Xgf180mcu_fd_sc_mcu9t5v0__fill_16_52 VDD VSS VSS VSS
+ gf180mcu_fd_sc_mcu9t5v0__fill_16
* cell instance gf180mcu_fd_sc_mcu9t5v0__fill_16_53 r0 *1 0,0
Xgf180mcu_fd_sc_mcu9t5v0__fill_16_53 VDD VDD VDD VSS
+ gf180mcu_fd_sc_mcu9t5v0__fill_16
* cell instance gf180mcu_fd_sc_mcu9t5v0__fill_16_54 r0 *1 0,0
Xgf180mcu_fd_sc_mcu9t5v0__fill_16_54 VDD \_005_ \_005_ VSS
+ gf180mcu_fd_sc_mcu9t5v0__fill_16
* cell instance gf180mcu_fd_sc_mcu9t5v0__fill_16_55 r0 *1 0,0
Xgf180mcu_fd_sc_mcu9t5v0__fill_16_55 VDD
+ gf180mcu_fd_sc_mcu9t5v0__fill_16_55__VNW VDD VSS
+ gf180mcu_fd_sc_mcu9t5v0__fill_16
* cell instance gf180mcu_fd_sc_mcu9t5v0__fill_16_56 r0 *1 0,0
Xgf180mcu_fd_sc_mcu9t5v0__fill_16_56 VDD
+ gf180mcu_fd_sc_mcu9t5v0__fill_16_56__VNW VDD VSS
+ gf180mcu_fd_sc_mcu9t5v0__fill_16
* cell instance gf180mcu_fd_sc_mcu9t5v0__fill_16_57 r0 *1 0,0
Xgf180mcu_fd_sc_mcu9t5v0__fill_16_57 VDD
+ gf180mcu_fd_sc_mcu9t5v0__fill_16_57__VNW
+ gf180mcu_fd_sc_mcu9t5v0__fill_16_57__VPW VSS gf180mcu_fd_sc_mcu9t5v0__fill_16
* cell instance gf180mcu_fd_sc_mcu9t5v0__fill_16_58 r0 *1 0,0
Xgf180mcu_fd_sc_mcu9t5v0__fill_16_58 VDD
+ gf180mcu_fd_sc_mcu9t5v0__fill_16_58__VNW
+ gf180mcu_fd_sc_mcu9t5v0__fill_16_58__VPW VSS gf180mcu_fd_sc_mcu9t5v0__fill_16
* cell instance gf180mcu_fd_sc_mcu9t5v0__fill_16_59 r0 *1 0,0
Xgf180mcu_fd_sc_mcu9t5v0__fill_16_59 VDD
+ gf180mcu_fd_sc_mcu9t5v0__fill_16_59__VNW
+ gf180mcu_fd_sc_mcu9t5v0__fill_16_59__VPW VSS gf180mcu_fd_sc_mcu9t5v0__fill_16
* cell instance gf180mcu_fd_sc_mcu9t5v0__fill_16_60 r0 *1 0,0
Xgf180mcu_fd_sc_mcu9t5v0__fill_16_60 VDD
+ gf180mcu_fd_sc_mcu9t5v0__fill_16_60__VNW
+ gf180mcu_fd_sc_mcu9t5v0__fill_16_60__VPW VSS gf180mcu_fd_sc_mcu9t5v0__fill_16
* cell instance gf180mcu_fd_sc_mcu9t5v0__fill_16_61 r0 *1 0,0
Xgf180mcu_fd_sc_mcu9t5v0__fill_16_61 VDD
+ gf180mcu_fd_sc_mcu9t5v0__fill_16_61__VNW
+ gf180mcu_fd_sc_mcu9t5v0__fill_16_61__VPW VSS gf180mcu_fd_sc_mcu9t5v0__fill_16
* cell instance gf180mcu_fd_sc_mcu9t5v0__fill_16_62 r0 *1 0,0
Xgf180mcu_fd_sc_mcu9t5v0__fill_16_62 VDD
+ gf180mcu_fd_sc_mcu9t5v0__fill_16_62__VNW
+ gf180mcu_fd_sc_mcu9t5v0__fill_16_62__VPW VSS gf180mcu_fd_sc_mcu9t5v0__fill_16
* cell instance gf180mcu_fd_sc_mcu9t5v0__fill_16_63 r0 *1 0,0
Xgf180mcu_fd_sc_mcu9t5v0__fill_16_63 VDD \_077_
+ gf180mcu_fd_sc_mcu9t5v0__fill_16_63__VPW VSS gf180mcu_fd_sc_mcu9t5v0__fill_16
* cell instance gf180mcu_fd_sc_mcu9t5v0__fill_16_64 r0 *1 0,0
Xgf180mcu_fd_sc_mcu9t5v0__fill_16_64 VDD
+ gf180mcu_fd_sc_mcu9t5v0__fill_16_64__VNW
+ gf180mcu_fd_sc_mcu9t5v0__fill_16_64__VPW VSS gf180mcu_fd_sc_mcu9t5v0__fill_16
* cell instance gf180mcu_fd_sc_mcu9t5v0__fill_16_65 r0 *1 0,0
Xgf180mcu_fd_sc_mcu9t5v0__fill_16_65 VDD
+ gf180mcu_fd_sc_mcu9t5v0__fill_16_65__VNW
+ gf180mcu_fd_sc_mcu9t5v0__fill_16_65__VPW VSS gf180mcu_fd_sc_mcu9t5v0__fill_16
* cell instance gf180mcu_fd_sc_mcu9t5v0__fill_16_66 r0 *1 0,0
Xgf180mcu_fd_sc_mcu9t5v0__fill_16_66 VDD \_071_
+ gf180mcu_fd_sc_mcu9t5v0__fill_16_66__VPW VSS gf180mcu_fd_sc_mcu9t5v0__fill_16
* cell instance gf180mcu_fd_sc_mcu9t5v0__fill_16_67 r0 *1 0,0
Xgf180mcu_fd_sc_mcu9t5v0__fill_16_67 VDD
+ gf180mcu_fd_sc_mcu9t5v0__fill_16_67__VNW
+ gf180mcu_fd_sc_mcu9t5v0__fill_16_67__VPW VSS gf180mcu_fd_sc_mcu9t5v0__fill_16
* cell instance gf180mcu_fd_sc_mcu9t5v0__fill_16_68 r0 *1 0,0
Xgf180mcu_fd_sc_mcu9t5v0__fill_16_68 VDD
+ gf180mcu_fd_sc_mcu9t5v0__fill_16_68__VNW
+ gf180mcu_fd_sc_mcu9t5v0__fill_16_68__VPW VSS gf180mcu_fd_sc_mcu9t5v0__fill_16
* cell instance gf180mcu_fd_sc_mcu9t5v0__fill_16_69 r0 *1 0,0
Xgf180mcu_fd_sc_mcu9t5v0__fill_16_69 VDD
+ gf180mcu_fd_sc_mcu9t5v0__fill_16_69__VNW
+ gf180mcu_fd_sc_mcu9t5v0__fill_16_69__VPW VSS gf180mcu_fd_sc_mcu9t5v0__fill_16
* cell instance gf180mcu_fd_sc_mcu9t5v0__fill_16_70 r0 *1 0,0
Xgf180mcu_fd_sc_mcu9t5v0__fill_16_70 VDD
+ gf180mcu_fd_sc_mcu9t5v0__fill_16_70__VNW VDD VSS
+ gf180mcu_fd_sc_mcu9t5v0__fill_16
* cell instance gf180mcu_fd_sc_mcu9t5v0__fill_16_71 r0 *1 0,0
Xgf180mcu_fd_sc_mcu9t5v0__fill_16_71 VDD
+ gf180mcu_fd_sc_mcu9t5v0__fill_16_71__VNW
+ gf180mcu_fd_sc_mcu9t5v0__fill_16_71__VPW VSS gf180mcu_fd_sc_mcu9t5v0__fill_16
* cell instance gf180mcu_fd_sc_mcu9t5v0__fill_16_72 r0 *1 0,0
Xgf180mcu_fd_sc_mcu9t5v0__fill_16_72 VDD
+ gf180mcu_fd_sc_mcu9t5v0__fill_16_72__VNW
+ gf180mcu_fd_sc_mcu9t5v0__fill_16_72__VPW VSS gf180mcu_fd_sc_mcu9t5v0__fill_16
* cell instance gf180mcu_fd_sc_mcu9t5v0__fill_16_73 r0 *1 0,0
Xgf180mcu_fd_sc_mcu9t5v0__fill_16_73 VDD byte_idx[2]
+ gf180mcu_fd_sc_mcu9t5v0__fill_16_73__VPW VSS gf180mcu_fd_sc_mcu9t5v0__fill_16
* cell instance gf180mcu_fd_sc_mcu9t5v0__fill_16_74 r0 *1 0,0
Xgf180mcu_fd_sc_mcu9t5v0__fill_16_74 VDD VSS VSS VSS
+ gf180mcu_fd_sc_mcu9t5v0__fill_16
* cell instance gf180mcu_fd_sc_mcu9t5v0__fill_16_75 r0 *1 0,0
Xgf180mcu_fd_sc_mcu9t5v0__fill_16_75 VDD
+ gf180mcu_fd_sc_mcu9t5v0__fill_16_75__VNW
+ gf180mcu_fd_sc_mcu9t5v0__fill_16_75__VPW VSS gf180mcu_fd_sc_mcu9t5v0__fill_16
* cell instance gf180mcu_fd_sc_mcu9t5v0__fill_16_76 r0 *1 0,0
Xgf180mcu_fd_sc_mcu9t5v0__fill_16_76 VDD
+ gf180mcu_fd_sc_mcu9t5v0__fill_16_76__VNW
+ gf180mcu_fd_sc_mcu9t5v0__fill_16_76__VPW VSS gf180mcu_fd_sc_mcu9t5v0__fill_16
* cell instance gf180mcu_fd_sc_mcu9t5v0__fill_16_77 r0 *1 0,0
Xgf180mcu_fd_sc_mcu9t5v0__fill_16_77 VDD
+ gf180mcu_fd_sc_mcu9t5v0__fill_16_77__VNW
+ gf180mcu_fd_sc_mcu9t5v0__fill_16_77__VPW VSS gf180mcu_fd_sc_mcu9t5v0__fill_16
* cell instance gf180mcu_fd_sc_mcu9t5v0__fill_16_78 r0 *1 0,0
Xgf180mcu_fd_sc_mcu9t5v0__fill_16_78 VDD
+ gf180mcu_fd_sc_mcu9t5v0__fill_16_78__VNW
+ gf180mcu_fd_sc_mcu9t5v0__fill_16_78__VPW VSS gf180mcu_fd_sc_mcu9t5v0__fill_16
* cell instance gf180mcu_fd_sc_mcu9t5v0__fill_16_79 r0 *1 0,0
Xgf180mcu_fd_sc_mcu9t5v0__fill_16_79 VDD VSS
+ gf180mcu_fd_sc_mcu9t5v0__fill_16_79__VPW VSS gf180mcu_fd_sc_mcu9t5v0__fill_16
* cell instance gf180mcu_fd_sc_mcu9t5v0__fill_16_80 r0 *1 0,0
Xgf180mcu_fd_sc_mcu9t5v0__fill_16_80 VDD
+ gf180mcu_fd_sc_mcu9t5v0__fill_16_80__VNW
+ gf180mcu_fd_sc_mcu9t5v0__fill_16_80__VPW VSS gf180mcu_fd_sc_mcu9t5v0__fill_16
* cell instance gf180mcu_fd_sc_mcu9t5v0__fill_16_81 r0 *1 0,0
Xgf180mcu_fd_sc_mcu9t5v0__fill_16_81 VDD
+ gf180mcu_fd_sc_mcu9t5v0__fill_16_81__VNW
+ gf180mcu_fd_sc_mcu9t5v0__fill_16_81__VPW VSS gf180mcu_fd_sc_mcu9t5v0__fill_16
* cell instance gf180mcu_fd_sc_mcu9t5v0__fill_16_82 r0 *1 0,0
Xgf180mcu_fd_sc_mcu9t5v0__fill_16_82 VDD
+ gf180mcu_fd_sc_mcu9t5v0__fill_16_82__VNW
+ gf180mcu_fd_sc_mcu9t5v0__fill_16_82__VPW VSS gf180mcu_fd_sc_mcu9t5v0__fill_16
* cell instance gf180mcu_fd_sc_mcu9t5v0__fill_16_83 r0 *1 0,0
Xgf180mcu_fd_sc_mcu9t5v0__fill_16_83 VDD
+ gf180mcu_fd_sc_mcu9t5v0__fill_16_83__VNW
+ gf180mcu_fd_sc_mcu9t5v0__fill_16_83__VPW VSS gf180mcu_fd_sc_mcu9t5v0__fill_16
* cell instance gf180mcu_fd_sc_mcu9t5v0__fill_16_84 r0 *1 0,0
Xgf180mcu_fd_sc_mcu9t5v0__fill_16_84 VDD
+ gf180mcu_fd_sc_mcu9t5v0__fill_16_84__VNW
+ gf180mcu_fd_sc_mcu9t5v0__fill_16_84__VPW VSS gf180mcu_fd_sc_mcu9t5v0__fill_16
* cell instance gf180mcu_fd_sc_mcu9t5v0__fill_2_0 r0 *1 0,0
Xgf180mcu_fd_sc_mcu9t5v0__fill_2_0 VDD gf180mcu_fd_sc_mcu9t5v0__fill_2_0__VNW
+ gf180mcu_fd_sc_mcu9t5v0__fill_2_0__VPW VSS gf180mcu_fd_sc_mcu9t5v0__fill_2
* cell instance gf180mcu_fd_sc_mcu9t5v0__fill_2_1 r0 *1 0,0
Xgf180mcu_fd_sc_mcu9t5v0__fill_2_1 VDD VSS
+ gf180mcu_fd_sc_mcu9t5v0__fill_2_1__VPW VSS gf180mcu_fd_sc_mcu9t5v0__fill_2
* cell instance gf180mcu_fd_sc_mcu9t5v0__fill_2_2 r0 *1 0,0
Xgf180mcu_fd_sc_mcu9t5v0__fill_2_2 VDD gf180mcu_fd_sc_mcu9t5v0__fill_2_2__VNW
+ gf180mcu_fd_sc_mcu9t5v0__fill_2_2__VPW VSS gf180mcu_fd_sc_mcu9t5v0__fill_2
* cell instance gf180mcu_fd_sc_mcu9t5v0__fill_2_3 r0 *1 0,0
Xgf180mcu_fd_sc_mcu9t5v0__fill_2_3 VDD gf180mcu_fd_sc_mcu9t5v0__fill_2_3__VNW
+ clknet_3_0__leaf_clk VSS gf180mcu_fd_sc_mcu9t5v0__fill_2
* cell instance gf180mcu_fd_sc_mcu9t5v0__fill_2_4 r0 *1 0,0
Xgf180mcu_fd_sc_mcu9t5v0__fill_2_4 VDD gf180mcu_fd_sc_mcu9t5v0__fill_2_4__VNW
+ gf180mcu_fd_sc_mcu9t5v0__fill_2_4__VPW VSS gf180mcu_fd_sc_mcu9t5v0__fill_2
* cell instance gf180mcu_fd_sc_mcu9t5v0__fill_2_5 r0 *1 0,0
Xgf180mcu_fd_sc_mcu9t5v0__fill_2_5 VDD gf180mcu_fd_sc_mcu9t5v0__fill_2_5__VNW
+ gf180mcu_fd_sc_mcu9t5v0__fill_2_5__VPW VSS gf180mcu_fd_sc_mcu9t5v0__fill_2
* cell instance gf180mcu_fd_sc_mcu9t5v0__fill_2_6 r0 *1 0,0
Xgf180mcu_fd_sc_mcu9t5v0__fill_2_6 VDD VSS
+ gf180mcu_fd_sc_mcu9t5v0__fill_2_6__VPW VSS gf180mcu_fd_sc_mcu9t5v0__fill_2
* cell instance gf180mcu_fd_sc_mcu9t5v0__fill_2_7 r0 *1 0,0
Xgf180mcu_fd_sc_mcu9t5v0__fill_2_7 VDD gf180mcu_fd_sc_mcu9t5v0__fill_2_7__VNW
+ VDD VSS gf180mcu_fd_sc_mcu9t5v0__fill_2
* cell instance gf180mcu_fd_sc_mcu9t5v0__fill_2_8 r0 *1 0,0
Xgf180mcu_fd_sc_mcu9t5v0__fill_2_8 VDD gf180mcu_fd_sc_mcu9t5v0__fill_2_8__VNW
+ gf180mcu_fd_sc_mcu9t5v0__fill_2_8__VPW VSS gf180mcu_fd_sc_mcu9t5v0__fill_2
* cell instance gf180mcu_fd_sc_mcu9t5v0__fill_2_9 r0 *1 0,0
Xgf180mcu_fd_sc_mcu9t5v0__fill_2_9 VDD gf180mcu_fd_sc_mcu9t5v0__fill_2_9__VNW
+ VDD VSS gf180mcu_fd_sc_mcu9t5v0__fill_2
* cell instance gf180mcu_fd_sc_mcu9t5v0__fill_2_10 r0 *1 0,0
Xgf180mcu_fd_sc_mcu9t5v0__fill_2_10 VDD gf180mcu_fd_sc_mcu9t5v0__fill_2_10__VNW
+ gf180mcu_fd_sc_mcu9t5v0__fill_2_10__VPW VSS gf180mcu_fd_sc_mcu9t5v0__fill_2
* cell instance gf180mcu_fd_sc_mcu9t5v0__fill_2_11 r0 *1 0,0
Xgf180mcu_fd_sc_mcu9t5v0__fill_2_11 VDD \_117_
+ gf180mcu_fd_sc_mcu9t5v0__fill_2_11__VPW VSS gf180mcu_fd_sc_mcu9t5v0__fill_2
* cell instance gf180mcu_fd_sc_mcu9t5v0__fill_2_12 r0 *1 0,0
Xgf180mcu_fd_sc_mcu9t5v0__fill_2_12 VDD \_056_ \_056_ VSS
+ gf180mcu_fd_sc_mcu9t5v0__fill_2
* cell instance gf180mcu_fd_sc_mcu9t5v0__fill_2_13 r0 *1 0,0
Xgf180mcu_fd_sc_mcu9t5v0__fill_2_13 VDD VSS VSS VSS
+ gf180mcu_fd_sc_mcu9t5v0__fill_2
* cell instance gf180mcu_fd_sc_mcu9t5v0__fill_2_14 r0 *1 0,0
Xgf180mcu_fd_sc_mcu9t5v0__fill_2_14 VDD VSS VSS VSS
+ gf180mcu_fd_sc_mcu9t5v0__fill_2
* cell instance gf180mcu_fd_sc_mcu9t5v0__fill_2_15 r0 *1 0,0
Xgf180mcu_fd_sc_mcu9t5v0__fill_2_15 VDD VSS VSS VSS
+ gf180mcu_fd_sc_mcu9t5v0__fill_2
* cell instance gf180mcu_fd_sc_mcu9t5v0__fill_2_16 r0 *1 0,0
Xgf180mcu_fd_sc_mcu9t5v0__fill_2_16 VDD VDD VDD VSS
+ gf180mcu_fd_sc_mcu9t5v0__fill_2
* cell instance gf180mcu_fd_sc_mcu9t5v0__fill_2_17 r0 *1 0,0
Xgf180mcu_fd_sc_mcu9t5v0__fill_2_17 VDD VDD VDD VSS
+ gf180mcu_fd_sc_mcu9t5v0__fill_2
* cell instance gf180mcu_fd_sc_mcu9t5v0__fill_2_18 r0 *1 0,0
Xgf180mcu_fd_sc_mcu9t5v0__fill_2_18 VDD gf180mcu_fd_sc_mcu9t5v0__fill_2_18__VNW
+ gf180mcu_fd_sc_mcu9t5v0__fill_2_18__VPW VSS gf180mcu_fd_sc_mcu9t5v0__fill_2
* cell instance gf180mcu_fd_sc_mcu9t5v0__fill_2_19 r0 *1 0,0
Xgf180mcu_fd_sc_mcu9t5v0__fill_2_19 VDD VDD VDD VSS
+ gf180mcu_fd_sc_mcu9t5v0__fill_2
* cell instance gf180mcu_fd_sc_mcu9t5v0__fill_2_20 r0 *1 0,0
Xgf180mcu_fd_sc_mcu9t5v0__fill_2_20 VDD VDD VDD VSS
+ gf180mcu_fd_sc_mcu9t5v0__fill_2
* cell instance gf180mcu_fd_sc_mcu9t5v0__fill_2_21 r0 *1 0,0
Xgf180mcu_fd_sc_mcu9t5v0__fill_2_21 VDD gf180mcu_fd_sc_mcu9t5v0__fill_2_21__VNW
+ gf180mcu_fd_sc_mcu9t5v0__fill_2_21__VPW VSS gf180mcu_fd_sc_mcu9t5v0__fill_2
* cell instance gf180mcu_fd_sc_mcu9t5v0__fill_2_22 r0 *1 0,0
Xgf180mcu_fd_sc_mcu9t5v0__fill_2_22 VDD gf180mcu_fd_sc_mcu9t5v0__fill_2_22__VNW
+ gf180mcu_fd_sc_mcu9t5v0__fill_2_22__VPW VSS gf180mcu_fd_sc_mcu9t5v0__fill_2
* cell instance gf180mcu_fd_sc_mcu9t5v0__fill_2_23 r0 *1 0,0
Xgf180mcu_fd_sc_mcu9t5v0__fill_2_23 VDD gf180mcu_fd_sc_mcu9t5v0__fill_2_23__VNW
+ gf180mcu_fd_sc_mcu9t5v0__fill_2_23__VPW VSS gf180mcu_fd_sc_mcu9t5v0__fill_2
* cell instance gf180mcu_fd_sc_mcu9t5v0__fill_2_24 r0 *1 0,0
Xgf180mcu_fd_sc_mcu9t5v0__fill_2_24 VDD rx_shift[6] rx_shift[6] VSS
+ gf180mcu_fd_sc_mcu9t5v0__fill_2
* cell instance gf180mcu_fd_sc_mcu9t5v0__fill_2_25 r0 *1 0,0
Xgf180mcu_fd_sc_mcu9t5v0__fill_2_25 VDD gf180mcu_fd_sc_mcu9t5v0__fill_2_25__VNW
+ gf180mcu_fd_sc_mcu9t5v0__fill_2_25__VPW VSS gf180mcu_fd_sc_mcu9t5v0__fill_2
* cell instance gf180mcu_fd_sc_mcu9t5v0__fill_2_26 r0 *1 0,0
Xgf180mcu_fd_sc_mcu9t5v0__fill_2_26 VDD u_destuffer/_07_ u_destuffer/_07_ VSS
+ gf180mcu_fd_sc_mcu9t5v0__fill_2
* cell instance gf180mcu_fd_sc_mcu9t5v0__fill_2_27 r0 *1 0,0
Xgf180mcu_fd_sc_mcu9t5v0__fill_2_27 VDD VSS
+ gf180mcu_fd_sc_mcu9t5v0__fill_2_27__VPW VSS gf180mcu_fd_sc_mcu9t5v0__fill_2
* cell instance gf180mcu_fd_sc_mcu9t5v0__fill_2_28 r0 *1 0,0
Xgf180mcu_fd_sc_mcu9t5v0__fill_2_28 VDD \_002_
+ gf180mcu_fd_sc_mcu9t5v0__fill_2_28__VPW VSS gf180mcu_fd_sc_mcu9t5v0__fill_2
* cell instance gf180mcu_fd_sc_mcu9t5v0__fill_2_29 r0 *1 0,0
Xgf180mcu_fd_sc_mcu9t5v0__fill_2_29 VDD VSS
+ gf180mcu_fd_sc_mcu9t5v0__fill_2_29__VPW VSS gf180mcu_fd_sc_mcu9t5v0__fill_2
* cell instance gf180mcu_fd_sc_mcu9t5v0__fill_2_30 r0 *1 0,0
Xgf180mcu_fd_sc_mcu9t5v0__fill_2_30 VDD gf180mcu_fd_sc_mcu9t5v0__fill_2_30__VNW
+ gf180mcu_fd_sc_mcu9t5v0__fill_2_30__VPW VSS gf180mcu_fd_sc_mcu9t5v0__fill_2
* cell instance gf180mcu_fd_sc_mcu9t5v0__fill_2_31 r0 *1 0,0
Xgf180mcu_fd_sc_mcu9t5v0__fill_2_31 VDD gf180mcu_fd_sc_mcu9t5v0__fill_2_31__VNW
+ gf180mcu_fd_sc_mcu9t5v0__fill_2_31__VPW VSS gf180mcu_fd_sc_mcu9t5v0__fill_2
* cell instance gf180mcu_fd_sc_mcu9t5v0__fill_2_32 r0 *1 0,0
Xgf180mcu_fd_sc_mcu9t5v0__fill_2_32 VDD gf180mcu_fd_sc_mcu9t5v0__fill_2_32__VNW
+ gf180mcu_fd_sc_mcu9t5v0__fill_2_32__VPW VSS gf180mcu_fd_sc_mcu9t5v0__fill_2
* cell instance gf180mcu_fd_sc_mcu9t5v0__fill_2_33 r0 *1 0,0
Xgf180mcu_fd_sc_mcu9t5v0__fill_2_33 VDD gf180mcu_fd_sc_mcu9t5v0__fill_2_33__VNW
+ gf180mcu_fd_sc_mcu9t5v0__fill_2_33__VPW VSS gf180mcu_fd_sc_mcu9t5v0__fill_2
* cell instance gf180mcu_fd_sc_mcu9t5v0__fill_2_34 r0 *1 0,0
Xgf180mcu_fd_sc_mcu9t5v0__fill_2_34 VDD gf180mcu_fd_sc_mcu9t5v0__fill_2_34__VNW
+ gf180mcu_fd_sc_mcu9t5v0__fill_2_34__VPW VSS gf180mcu_fd_sc_mcu9t5v0__fill_2
* cell instance gf180mcu_fd_sc_mcu9t5v0__fill_2_35 r0 *1 0,0
Xgf180mcu_fd_sc_mcu9t5v0__fill_2_35 VDD DataIn[2]
+ gf180mcu_fd_sc_mcu9t5v0__fill_2_35__VPW VSS gf180mcu_fd_sc_mcu9t5v0__fill_2
* cell instance gf180mcu_fd_sc_mcu9t5v0__fill_2_36 r0 *1 0,0
Xgf180mcu_fd_sc_mcu9t5v0__fill_2_36 VDD gf180mcu_fd_sc_mcu9t5v0__fill_2_36__VNW
+ gf180mcu_fd_sc_mcu9t5v0__fill_2_36__VPW VSS gf180mcu_fd_sc_mcu9t5v0__fill_2
* cell instance gf180mcu_fd_sc_mcu9t5v0__fill_2_37 r0 *1 0,0
Xgf180mcu_fd_sc_mcu9t5v0__fill_2_37 VDD gf180mcu_fd_sc_mcu9t5v0__fill_2_37__VNW
+ VDD VSS gf180mcu_fd_sc_mcu9t5v0__fill_2
* cell instance gf180mcu_fd_sc_mcu9t5v0__fill_2_38 r0 *1 0,0
Xgf180mcu_fd_sc_mcu9t5v0__fill_2_38 VDD gf180mcu_fd_sc_mcu9t5v0__fill_2_38__VNW
+ gf180mcu_fd_sc_mcu9t5v0__fill_2_38__VPW VSS gf180mcu_fd_sc_mcu9t5v0__fill_2
* cell instance gf180mcu_fd_sc_mcu9t5v0__fill_2_39 r0 *1 0,0
Xgf180mcu_fd_sc_mcu9t5v0__fill_2_39 VDD gf180mcu_fd_sc_mcu9t5v0__fill_2_39__VNW
+ gf180mcu_fd_sc_mcu9t5v0__fill_2_39__VPW VSS gf180mcu_fd_sc_mcu9t5v0__fill_2
* cell instance gf180mcu_fd_sc_mcu9t5v0__fill_2_40 r0 *1 0,0
Xgf180mcu_fd_sc_mcu9t5v0__fill_2_40 VDD u_sync_detector/_11_
+ u_sync_detector/_09_ VSS gf180mcu_fd_sc_mcu9t5v0__fill_2
* cell instance gf180mcu_fd_sc_mcu9t5v0__fill_2_41 r0 *1 0,0
Xgf180mcu_fd_sc_mcu9t5v0__fill_2_41 VDD rx_shift[1] clknet_0_clk VSS
+ gf180mcu_fd_sc_mcu9t5v0__fill_2
* cell instance gf180mcu_fd_sc_mcu9t5v0__fill_2_42 r0 *1 0,0
Xgf180mcu_fd_sc_mcu9t5v0__fill_2_42 VDD gf180mcu_fd_sc_mcu9t5v0__fill_2_42__VNW
+ VDD VSS gf180mcu_fd_sc_mcu9t5v0__fill_2
* cell instance gf180mcu_fd_sc_mcu9t5v0__fill_2_43 r0 *1 0,0
Xgf180mcu_fd_sc_mcu9t5v0__fill_2_43 VDD gf180mcu_fd_sc_mcu9t5v0__fill_2_43__VNW
+ gf180mcu_fd_sc_mcu9t5v0__fill_2_43__VPW VSS gf180mcu_fd_sc_mcu9t5v0__fill_2
* cell instance gf180mcu_fd_sc_mcu9t5v0__fill_2_44 r0 *1 0,0
Xgf180mcu_fd_sc_mcu9t5v0__fill_2_44 VDD VSS VSS VSS
+ gf180mcu_fd_sc_mcu9t5v0__fill_2
* cell instance gf180mcu_fd_sc_mcu9t5v0__fill_2_45 r0 *1 0,0
Xgf180mcu_fd_sc_mcu9t5v0__fill_2_45 VDD VSS VSS VSS
+ gf180mcu_fd_sc_mcu9t5v0__fill_2
* cell instance gf180mcu_fd_sc_mcu9t5v0__fill_2_46 r0 *1 0,0
Xgf180mcu_fd_sc_mcu9t5v0__fill_2_46 VDD VSS VSS VSS
+ gf180mcu_fd_sc_mcu9t5v0__fill_2
* cell instance gf180mcu_fd_sc_mcu9t5v0__fill_2_47 r0 *1 0,0
Xgf180mcu_fd_sc_mcu9t5v0__fill_2_47 VDD u_sync_detector/match[3] VSS VSS
+ gf180mcu_fd_sc_mcu9t5v0__fill_2
* cell instance gf180mcu_fd_sc_mcu9t5v0__fill_2_48 r0 *1 0,0
Xgf180mcu_fd_sc_mcu9t5v0__fill_2_48 VDD DataIn[1]
+ gf180mcu_fd_sc_mcu9t5v0__fill_2_48__VPW VSS gf180mcu_fd_sc_mcu9t5v0__fill_2
* cell instance gf180mcu_fd_sc_mcu9t5v0__fill_2_49 r0 *1 0,0
Xgf180mcu_fd_sc_mcu9t5v0__fill_2_49 VDD VDD VDD VSS
+ gf180mcu_fd_sc_mcu9t5v0__fill_2
* cell instance gf180mcu_fd_sc_mcu9t5v0__fill_2_50 r0 *1 0,0
Xgf180mcu_fd_sc_mcu9t5v0__fill_2_50 VDD VDD VDD VSS
+ gf180mcu_fd_sc_mcu9t5v0__fill_2
* cell instance gf180mcu_fd_sc_mcu9t5v0__fill_2_51 r0 *1 0,0
Xgf180mcu_fd_sc_mcu9t5v0__fill_2_51 VDD VDD VDD VSS
+ gf180mcu_fd_sc_mcu9t5v0__fill_2
* cell instance gf180mcu_fd_sc_mcu9t5v0__fill_2_52 r0 *1 0,0
Xgf180mcu_fd_sc_mcu9t5v0__fill_2_52 VDD VDD VDD VSS
+ gf180mcu_fd_sc_mcu9t5v0__fill_2
* cell instance gf180mcu_fd_sc_mcu9t5v0__fill_2_53 r0 *1 0,0
Xgf180mcu_fd_sc_mcu9t5v0__fill_2_53 VDD VDD VDD VSS
+ gf180mcu_fd_sc_mcu9t5v0__fill_2
* cell instance gf180mcu_fd_sc_mcu9t5v0__fill_2_54 r0 *1 0,0
Xgf180mcu_fd_sc_mcu9t5v0__fill_2_54 VDD VDD VDD VSS
+ gf180mcu_fd_sc_mcu9t5v0__fill_2
* cell instance gf180mcu_fd_sc_mcu9t5v0__fill_2_55 r0 *1 0,0
Xgf180mcu_fd_sc_mcu9t5v0__fill_2_55 VDD gf180mcu_fd_sc_mcu9t5v0__fill_2_55__VNW
+ gf180mcu_fd_sc_mcu9t5v0__fill_2_55__VPW VSS gf180mcu_fd_sc_mcu9t5v0__fill_2
* cell instance gf180mcu_fd_sc_mcu9t5v0__fill_2_56 r0 *1 0,0
Xgf180mcu_fd_sc_mcu9t5v0__fill_2_56 VDD gf180mcu_fd_sc_mcu9t5v0__fill_2_56__VNW
+ gf180mcu_fd_sc_mcu9t5v0__fill_2_56__VPW VSS gf180mcu_fd_sc_mcu9t5v0__fill_2
* cell instance gf180mcu_fd_sc_mcu9t5v0__fill_2_57 r0 *1 0,0
Xgf180mcu_fd_sc_mcu9t5v0__fill_2_57 VDD line_state[1]
+ gf180mcu_fd_sc_mcu9t5v0__fill_2_57__VPW VSS gf180mcu_fd_sc_mcu9t5v0__fill_2
* cell instance gf180mcu_fd_sc_mcu9t5v0__fill_2_58 r0 *1 0,0
Xgf180mcu_fd_sc_mcu9t5v0__fill_2_58 VDD gf180mcu_fd_sc_mcu9t5v0__fill_2_58__VNW
+ gf180mcu_fd_sc_mcu9t5v0__fill_2_58__VPW VSS gf180mcu_fd_sc_mcu9t5v0__fill_2
* cell instance gf180mcu_fd_sc_mcu9t5v0__fill_2_59 r0 *1 0,0
Xgf180mcu_fd_sc_mcu9t5v0__fill_2_59 VDD gf180mcu_fd_sc_mcu9t5v0__fill_2_59__VNW
+ gf180mcu_fd_sc_mcu9t5v0__fill_2_59__VPW VSS gf180mcu_fd_sc_mcu9t5v0__fill_2
* cell instance gf180mcu_fd_sc_mcu9t5v0__fill_2_60 r0 *1 0,0
Xgf180mcu_fd_sc_mcu9t5v0__fill_2_60 VDD gf180mcu_fd_sc_mcu9t5v0__fill_2_60__VNW
+ gf180mcu_fd_sc_mcu9t5v0__fill_2_60__VPW VSS gf180mcu_fd_sc_mcu9t5v0__fill_2
* cell instance gf180mcu_fd_sc_mcu9t5v0__fill_2_61 r0 *1 0,0
Xgf180mcu_fd_sc_mcu9t5v0__fill_2_61 VDD gf180mcu_fd_sc_mcu9t5v0__fill_2_61__VNW
+ gf180mcu_fd_sc_mcu9t5v0__fill_2_61__VPW VSS gf180mcu_fd_sc_mcu9t5v0__fill_2
* cell instance gf180mcu_fd_sc_mcu9t5v0__fill_2_62 r0 *1 0,0
Xgf180mcu_fd_sc_mcu9t5v0__fill_2_62 VDD gf180mcu_fd_sc_mcu9t5v0__fill_2_62__VNW
+ gf180mcu_fd_sc_mcu9t5v0__fill_2_62__VPW VSS gf180mcu_fd_sc_mcu9t5v0__fill_2
* cell instance gf180mcu_fd_sc_mcu9t5v0__fill_2_63 r0 *1 0,0
Xgf180mcu_fd_sc_mcu9t5v0__fill_2_63 VDD gf180mcu_fd_sc_mcu9t5v0__fill_2_63__VNW
+ gf180mcu_fd_sc_mcu9t5v0__fill_2_63__VPW VSS gf180mcu_fd_sc_mcu9t5v0__fill_2
* cell instance gf180mcu_fd_sc_mcu9t5v0__fill_2_64 r0 *1 0,0
Xgf180mcu_fd_sc_mcu9t5v0__fill_2_64 VDD VSS
+ gf180mcu_fd_sc_mcu9t5v0__fill_2_64__VPW VSS gf180mcu_fd_sc_mcu9t5v0__fill_2
* cell instance gf180mcu_fd_sc_mcu9t5v0__fill_2_65 r0 *1 0,0
Xgf180mcu_fd_sc_mcu9t5v0__fill_2_65 VDD DataIn[2]
+ gf180mcu_fd_sc_mcu9t5v0__fill_2_65__VPW VSS gf180mcu_fd_sc_mcu9t5v0__fill_2
* cell instance gf180mcu_fd_sc_mcu9t5v0__fill_2_66 r0 *1 0,0
Xgf180mcu_fd_sc_mcu9t5v0__fill_2_66 VDD gf180mcu_fd_sc_mcu9t5v0__fill_2_66__VNW
+ gf180mcu_fd_sc_mcu9t5v0__fill_2_66__VPW VSS gf180mcu_fd_sc_mcu9t5v0__fill_2
* cell instance gf180mcu_fd_sc_mcu9t5v0__fill_2_67 r0 *1 0,0
Xgf180mcu_fd_sc_mcu9t5v0__fill_2_67 VDD u_eop_detector/_26_ u_eop_detector/_26_
+ VSS gf180mcu_fd_sc_mcu9t5v0__fill_2
* cell instance gf180mcu_fd_sc_mcu9t5v0__fill_2_68 r0 *1 0,0
Xgf180mcu_fd_sc_mcu9t5v0__fill_2_68 VDD DataIn[0]
+ gf180mcu_fd_sc_mcu9t5v0__fill_2_68__VPW VSS gf180mcu_fd_sc_mcu9t5v0__fill_2
* cell instance gf180mcu_fd_sc_mcu9t5v0__fill_2_69 r0 *1 0,0
Xgf180mcu_fd_sc_mcu9t5v0__fill_2_69 VDD gf180mcu_fd_sc_mcu9t5v0__fill_2_69__VNW
+ gf180mcu_fd_sc_mcu9t5v0__fill_2_69__VPW VSS gf180mcu_fd_sc_mcu9t5v0__fill_2
* cell instance gf180mcu_fd_sc_mcu9t5v0__fill_2_70 r0 *1 0,0
Xgf180mcu_fd_sc_mcu9t5v0__fill_2_70 VDD u_eop_detector/se0_count[2]
+ gf180mcu_fd_sc_mcu9t5v0__fill_2_70__VPW VSS gf180mcu_fd_sc_mcu9t5v0__fill_2
* cell instance gf180mcu_fd_sc_mcu9t5v0__fill_2_71 r0 *1 0,0
Xgf180mcu_fd_sc_mcu9t5v0__fill_2_71 VDD gf180mcu_fd_sc_mcu9t5v0__fill_2_71__VNW
+ gf180mcu_fd_sc_mcu9t5v0__fill_2_71__VPW VSS gf180mcu_fd_sc_mcu9t5v0__fill_2
* cell instance gf180mcu_fd_sc_mcu9t5v0__fill_2_72 r0 *1 0,0
Xgf180mcu_fd_sc_mcu9t5v0__fill_2_72 VDD gf180mcu_fd_sc_mcu9t5v0__fill_2_72__VNW
+ VDD VSS gf180mcu_fd_sc_mcu9t5v0__fill_2
* cell instance gf180mcu_fd_sc_mcu9t5v0__fill_2_73 r0 *1 0,0
Xgf180mcu_fd_sc_mcu9t5v0__fill_2_73 VDD u_eop_detector/_00_ u_eop_detector/_00_
+ VSS gf180mcu_fd_sc_mcu9t5v0__fill_2
* cell instance gf180mcu_fd_sc_mcu9t5v0__fill_2_74 r0 *1 0,0
Xgf180mcu_fd_sc_mcu9t5v0__fill_2_74 VDD \_055_ \_055_ VSS
+ gf180mcu_fd_sc_mcu9t5v0__fill_2
* cell instance gf180mcu_fd_sc_mcu9t5v0__fill_2_75 r0 *1 0,0
Xgf180mcu_fd_sc_mcu9t5v0__fill_2_75 VDD gf180mcu_fd_sc_mcu9t5v0__fill_2_75__VNW
+ gf180mcu_fd_sc_mcu9t5v0__fill_2_75__VPW VSS gf180mcu_fd_sc_mcu9t5v0__fill_2
* cell instance gf180mcu_fd_sc_mcu9t5v0__fill_2_76 r0 *1 0,0
Xgf180mcu_fd_sc_mcu9t5v0__fill_2_76 VDD VSS
+ gf180mcu_fd_sc_mcu9t5v0__fill_2_76__VPW VSS gf180mcu_fd_sc_mcu9t5v0__fill_2
* cell instance gf180mcu_fd_sc_mcu9t5v0__fill_2_77 r0 *1 0,0
Xgf180mcu_fd_sc_mcu9t5v0__fill_2_77 VDD gf180mcu_fd_sc_mcu9t5v0__fill_2_77__VNW
+ gf180mcu_fd_sc_mcu9t5v0__fill_2_77__VPW VSS gf180mcu_fd_sc_mcu9t5v0__fill_2
* cell instance gf180mcu_fd_sc_mcu9t5v0__fill_2_78 r0 *1 0,0
Xgf180mcu_fd_sc_mcu9t5v0__fill_2_78 VDD gf180mcu_fd_sc_mcu9t5v0__fill_2_78__VNW
+ gf180mcu_fd_sc_mcu9t5v0__fill_2_78__VPW VSS gf180mcu_fd_sc_mcu9t5v0__fill_2
* cell instance gf180mcu_fd_sc_mcu9t5v0__fill_2_79 r0 *1 0,0
Xgf180mcu_fd_sc_mcu9t5v0__fill_2_79 VDD gf180mcu_fd_sc_mcu9t5v0__fill_2_79__VNW
+ VDD VSS gf180mcu_fd_sc_mcu9t5v0__fill_2
* cell instance gf180mcu_fd_sc_mcu9t5v0__fill_2_80 r0 *1 0,0
Xgf180mcu_fd_sc_mcu9t5v0__fill_2_80 VDD gf180mcu_fd_sc_mcu9t5v0__fill_2_80__VNW
+ gf180mcu_fd_sc_mcu9t5v0__fill_2_80__VPW VSS gf180mcu_fd_sc_mcu9t5v0__fill_2
* cell instance gf180mcu_fd_sc_mcu9t5v0__fill_2_81 r0 *1 0,0
Xgf180mcu_fd_sc_mcu9t5v0__fill_2_81 VDD rx_receiving rx_receiving VSS
+ gf180mcu_fd_sc_mcu9t5v0__fill_2
* cell instance gf180mcu_fd_sc_mcu9t5v0__fill_2_82 r0 *1 0,0
Xgf180mcu_fd_sc_mcu9t5v0__fill_2_82 VDD gf180mcu_fd_sc_mcu9t5v0__fill_2_82__VNW
+ gf180mcu_fd_sc_mcu9t5v0__fill_2_82__VPW VSS gf180mcu_fd_sc_mcu9t5v0__fill_2
* cell instance gf180mcu_fd_sc_mcu9t5v0__fill_2_83 r0 *1 0,0
Xgf180mcu_fd_sc_mcu9t5v0__fill_2_83 VDD gf180mcu_fd_sc_mcu9t5v0__fill_2_83__VNW
+ gf180mcu_fd_sc_mcu9t5v0__fill_2_83__VPW VSS gf180mcu_fd_sc_mcu9t5v0__fill_2
* cell instance gf180mcu_fd_sc_mcu9t5v0__fill_2_84 r0 *1 0,0
Xgf180mcu_fd_sc_mcu9t5v0__fill_2_84 VDD gf180mcu_fd_sc_mcu9t5v0__fill_2_84__VNW
+ gf180mcu_fd_sc_mcu9t5v0__fill_2_84__VPW VSS gf180mcu_fd_sc_mcu9t5v0__fill_2
* cell instance gf180mcu_fd_sc_mcu9t5v0__fill_2_85 r0 *1 0,0
Xgf180mcu_fd_sc_mcu9t5v0__fill_2_85 VDD gf180mcu_fd_sc_mcu9t5v0__fill_2_85__VNW
+ txdp VSS gf180mcu_fd_sc_mcu9t5v0__fill_2
* cell instance gf180mcu_fd_sc_mcu9t5v0__fill_2_86 r0 *1 0,0
Xgf180mcu_fd_sc_mcu9t5v0__fill_2_86 VDD u_encoder/_1_ u_encoder/_1_ VSS
+ gf180mcu_fd_sc_mcu9t5v0__fill_2
* cell instance gf180mcu_fd_sc_mcu9t5v0__fill_2_87 r0 *1 0,0
Xgf180mcu_fd_sc_mcu9t5v0__fill_2_87 VDD OpMode[0] OpMode[0] VSS
+ gf180mcu_fd_sc_mcu9t5v0__fill_2
* cell instance gf180mcu_fd_sc_mcu9t5v0__fill_2_88 r0 *1 0,0
Xgf180mcu_fd_sc_mcu9t5v0__fill_2_88 VDD gf180mcu_fd_sc_mcu9t5v0__fill_2_88__VNW
+ gf180mcu_fd_sc_mcu9t5v0__fill_2_88__VPW VSS gf180mcu_fd_sc_mcu9t5v0__fill_2
* cell instance gf180mcu_fd_sc_mcu9t5v0__fill_2_89 r0 *1 0,0
Xgf180mcu_fd_sc_mcu9t5v0__fill_2_89 VDD VSS
+ gf180mcu_fd_sc_mcu9t5v0__fill_2_89__VPW VSS gf180mcu_fd_sc_mcu9t5v0__fill_2
* cell instance gf180mcu_fd_sc_mcu9t5v0__fill_2_90 r0 *1 0,0
Xgf180mcu_fd_sc_mcu9t5v0__fill_2_90 VDD gf180mcu_fd_sc_mcu9t5v0__fill_2_90__VNW
+ gf180mcu_fd_sc_mcu9t5v0__fill_2_90__VPW VSS gf180mcu_fd_sc_mcu9t5v0__fill_2
* cell instance gf180mcu_fd_sc_mcu9t5v0__fill_2_91 r0 *1 0,0
Xgf180mcu_fd_sc_mcu9t5v0__fill_2_91 VDD gf180mcu_fd_sc_mcu9t5v0__fill_2_91__VNW
+ gf180mcu_fd_sc_mcu9t5v0__fill_2_91__VPW VSS gf180mcu_fd_sc_mcu9t5v0__fill_2
* cell instance gf180mcu_fd_sc_mcu9t5v0__fill_2_92 r0 *1 0,0
Xgf180mcu_fd_sc_mcu9t5v0__fill_2_92 VDD gf180mcu_fd_sc_mcu9t5v0__fill_2_92__VNW
+ gf180mcu_fd_sc_mcu9t5v0__fill_2_92__VPW VSS gf180mcu_fd_sc_mcu9t5v0__fill_2
* cell instance gf180mcu_fd_sc_mcu9t5v0__fill_2_93 r0 *1 0,0
Xgf180mcu_fd_sc_mcu9t5v0__fill_2_93 VDD gf180mcu_fd_sc_mcu9t5v0__fill_2_93__VNW
+ gf180mcu_fd_sc_mcu9t5v0__fill_2_93__VPW VSS gf180mcu_fd_sc_mcu9t5v0__fill_2
* cell instance gf180mcu_fd_sc_mcu9t5v0__fill_2_94 r0 *1 0,0
Xgf180mcu_fd_sc_mcu9t5v0__fill_2_94 VDD u_eop_detector/_18_
+ gf180mcu_fd_sc_mcu9t5v0__fill_2_94__VPW VSS gf180mcu_fd_sc_mcu9t5v0__fill_2
* cell instance gf180mcu_fd_sc_mcu9t5v0__fill_2_95 r0 *1 0,0
Xgf180mcu_fd_sc_mcu9t5v0__fill_2_95 VDD VSS VSS VSS
+ gf180mcu_fd_sc_mcu9t5v0__fill_2
* cell instance gf180mcu_fd_sc_mcu9t5v0__fill_2_96 r0 *1 0,0
Xgf180mcu_fd_sc_mcu9t5v0__fill_2_96 VDD VSS VSS VSS
+ gf180mcu_fd_sc_mcu9t5v0__fill_2
* cell instance gf180mcu_fd_sc_mcu9t5v0__fill_2_97 r0 *1 0,0
Xgf180mcu_fd_sc_mcu9t5v0__fill_2_97 VDD VSS VSS VSS
+ gf180mcu_fd_sc_mcu9t5v0__fill_2
* cell instance gf180mcu_fd_sc_mcu9t5v0__fill_2_98 r0 *1 0,0
Xgf180mcu_fd_sc_mcu9t5v0__fill_2_98 VDD u_stuffer/_11_ u_stuffer/_12_ VSS
+ gf180mcu_fd_sc_mcu9t5v0__fill_2
* cell instance gf180mcu_fd_sc_mcu9t5v0__fill_2_99 r0 *1 0,0
Xgf180mcu_fd_sc_mcu9t5v0__fill_2_99 VDD VSS VSS VSS
+ gf180mcu_fd_sc_mcu9t5v0__fill_2
* cell instance gf180mcu_fd_sc_mcu9t5v0__fill_2_100 r0 *1 0,0
Xgf180mcu_fd_sc_mcu9t5v0__fill_2_100 VDD VSS VSS VSS
+ gf180mcu_fd_sc_mcu9t5v0__fill_2
* cell instance gf180mcu_fd_sc_mcu9t5v0__fill_2_101 r0 *1 0,0
Xgf180mcu_fd_sc_mcu9t5v0__fill_2_101 VDD VSS VSS VSS
+ gf180mcu_fd_sc_mcu9t5v0__fill_2
* cell instance gf180mcu_fd_sc_mcu9t5v0__fill_2_102 r0 *1 0,0
Xgf180mcu_fd_sc_mcu9t5v0__fill_2_102 VDD u_eop_detector/_21_ VSS VSS
+ gf180mcu_fd_sc_mcu9t5v0__fill_2
* cell instance gf180mcu_fd_sc_mcu9t5v0__fill_2_103 r0 *1 0,0
Xgf180mcu_fd_sc_mcu9t5v0__fill_2_103 VDD \_005_ \_005_ VSS
+ gf180mcu_fd_sc_mcu9t5v0__fill_2
* cell instance gf180mcu_fd_sc_mcu9t5v0__fill_2_104 r0 *1 0,0
Xgf180mcu_fd_sc_mcu9t5v0__fill_2_104 VDD \_005_ \_005_ VSS
+ gf180mcu_fd_sc_mcu9t5v0__fill_2
* cell instance gf180mcu_fd_sc_mcu9t5v0__fill_2_105 r0 *1 0,0
Xgf180mcu_fd_sc_mcu9t5v0__fill_2_105 VDD VDD VDD VSS
+ gf180mcu_fd_sc_mcu9t5v0__fill_2
* cell instance gf180mcu_fd_sc_mcu9t5v0__fill_2_106 r0 *1 0,0
Xgf180mcu_fd_sc_mcu9t5v0__fill_2_106 VDD VDD VDD VSS
+ gf180mcu_fd_sc_mcu9t5v0__fill_2
* cell instance gf180mcu_fd_sc_mcu9t5v0__fill_2_107 r0 *1 0,0
Xgf180mcu_fd_sc_mcu9t5v0__fill_2_107 VDD VDD VDD VSS
+ gf180mcu_fd_sc_mcu9t5v0__fill_2
* cell instance gf180mcu_fd_sc_mcu9t5v0__fill_2_108 r0 *1 0,0
Xgf180mcu_fd_sc_mcu9t5v0__fill_2_108 VDD VDD VDD VSS
+ gf180mcu_fd_sc_mcu9t5v0__fill_2
* cell instance gf180mcu_fd_sc_mcu9t5v0__fill_2_109 r0 *1 0,0
Xgf180mcu_fd_sc_mcu9t5v0__fill_2_109 VDD
+ gf180mcu_fd_sc_mcu9t5v0__fill_2_109__VNW
+ gf180mcu_fd_sc_mcu9t5v0__fill_2_109__VPW VSS gf180mcu_fd_sc_mcu9t5v0__fill_2
* cell instance gf180mcu_fd_sc_mcu9t5v0__fill_2_110 r0 *1 0,0
Xgf180mcu_fd_sc_mcu9t5v0__fill_2_110 VDD stuff_consume stuff_consume VSS
+ gf180mcu_fd_sc_mcu9t5v0__fill_2
* cell instance gf180mcu_fd_sc_mcu9t5v0__fill_2_111 r0 *1 0,0
Xgf180mcu_fd_sc_mcu9t5v0__fill_2_111 VDD
+ gf180mcu_fd_sc_mcu9t5v0__fill_2_111__VNW
+ gf180mcu_fd_sc_mcu9t5v0__fill_2_111__VPW VSS gf180mcu_fd_sc_mcu9t5v0__fill_2
* cell instance gf180mcu_fd_sc_mcu9t5v0__fill_2_112 r0 *1 0,0
Xgf180mcu_fd_sc_mcu9t5v0__fill_2_112 VDD clknet_3_5__leaf_clk
+ clknet_3_5__leaf_clk VSS gf180mcu_fd_sc_mcu9t5v0__fill_2
* cell instance gf180mcu_fd_sc_mcu9t5v0__fill_2_113 r0 *1 0,0
Xgf180mcu_fd_sc_mcu9t5v0__fill_2_113 VDD
+ gf180mcu_fd_sc_mcu9t5v0__fill_2_113__VNW VDD VSS
+ gf180mcu_fd_sc_mcu9t5v0__fill_2
* cell instance gf180mcu_fd_sc_mcu9t5v0__fill_2_114 r0 *1 0,0
Xgf180mcu_fd_sc_mcu9t5v0__fill_2_114 VDD
+ gf180mcu_fd_sc_mcu9t5v0__fill_2_114__VNW
+ gf180mcu_fd_sc_mcu9t5v0__fill_2_114__VPW VSS gf180mcu_fd_sc_mcu9t5v0__fill_2
* cell instance gf180mcu_fd_sc_mcu9t5v0__fill_2_115 r0 *1 0,0
Xgf180mcu_fd_sc_mcu9t5v0__fill_2_115 VDD
+ gf180mcu_fd_sc_mcu9t5v0__fill_2_115__VNW
+ gf180mcu_fd_sc_mcu9t5v0__fill_2_115__VPW VSS gf180mcu_fd_sc_mcu9t5v0__fill_2
* cell instance gf180mcu_fd_sc_mcu9t5v0__fill_2_116 r0 *1 0,0
Xgf180mcu_fd_sc_mcu9t5v0__fill_2_116 VDD byte_idx[2]
+ gf180mcu_fd_sc_mcu9t5v0__fill_2_116__VPW VSS gf180mcu_fd_sc_mcu9t5v0__fill_2
* cell instance gf180mcu_fd_sc_mcu9t5v0__fill_2_117 r0 *1 0,0
Xgf180mcu_fd_sc_mcu9t5v0__fill_2_117 VDD stuff_consume stuff_consume VSS
+ gf180mcu_fd_sc_mcu9t5v0__fill_2
* cell instance gf180mcu_fd_sc_mcu9t5v0__fill_2_118 r0 *1 0,0
Xgf180mcu_fd_sc_mcu9t5v0__fill_2_118 VDD
+ gf180mcu_fd_sc_mcu9t5v0__fill_2_118__VNW
+ gf180mcu_fd_sc_mcu9t5v0__fill_2_118__VPW VSS gf180mcu_fd_sc_mcu9t5v0__fill_2
* cell instance gf180mcu_fd_sc_mcu9t5v0__fill_2_119 r0 *1 0,0
Xgf180mcu_fd_sc_mcu9t5v0__fill_2_119 VDD
+ gf180mcu_fd_sc_mcu9t5v0__fill_2_119__VNW
+ gf180mcu_fd_sc_mcu9t5v0__fill_2_119__VPW VSS gf180mcu_fd_sc_mcu9t5v0__fill_2
* cell instance gf180mcu_fd_sc_mcu9t5v0__fill_2_120 r0 *1 0,0
Xgf180mcu_fd_sc_mcu9t5v0__fill_2_120 VDD
+ gf180mcu_fd_sc_mcu9t5v0__fill_2_120__VNW
+ gf180mcu_fd_sc_mcu9t5v0__fill_2_120__VPW VSS gf180mcu_fd_sc_mcu9t5v0__fill_2
* cell instance gf180mcu_fd_sc_mcu9t5v0__fill_2_121 r0 *1 0,0
Xgf180mcu_fd_sc_mcu9t5v0__fill_2_121 VDD
+ gf180mcu_fd_sc_mcu9t5v0__fill_2_121__VNW
+ gf180mcu_fd_sc_mcu9t5v0__fill_2_121__VPW VSS gf180mcu_fd_sc_mcu9t5v0__fill_2
* cell instance gf180mcu_fd_sc_mcu9t5v0__fill_2_122 r0 *1 0,0
Xgf180mcu_fd_sc_mcu9t5v0__fill_2_122 VDD clknet_3_5__leaf_clk
+ gf180mcu_fd_sc_mcu9t5v0__fill_2_122__VPW VSS gf180mcu_fd_sc_mcu9t5v0__fill_2
* cell instance gf180mcu_fd_sc_mcu9t5v0__fill_2_123 r0 *1 0,0
Xgf180mcu_fd_sc_mcu9t5v0__fill_2_123 VDD VSS tx_state[1] VSS
+ gf180mcu_fd_sc_mcu9t5v0__fill_2
* cell instance gf180mcu_fd_sc_mcu9t5v0__fill_2_124 r0 *1 0,0
Xgf180mcu_fd_sc_mcu9t5v0__fill_2_124 VDD
+ gf180mcu_fd_sc_mcu9t5v0__fill_2_124__VNW
+ gf180mcu_fd_sc_mcu9t5v0__fill_2_124__VPW VSS gf180mcu_fd_sc_mcu9t5v0__fill_2
* cell instance gf180mcu_fd_sc_mcu9t5v0__fill_2_125 r0 *1 0,0
Xgf180mcu_fd_sc_mcu9t5v0__fill_2_125 VDD
+ gf180mcu_fd_sc_mcu9t5v0__fill_2_125__VNW
+ gf180mcu_fd_sc_mcu9t5v0__fill_2_125__VPW VSS gf180mcu_fd_sc_mcu9t5v0__fill_2
* cell instance gf180mcu_fd_sc_mcu9t5v0__fill_2_126 r0 *1 0,0
Xgf180mcu_fd_sc_mcu9t5v0__fill_2_126 VDD byte_reg[1] byte_reg[1] VSS
+ gf180mcu_fd_sc_mcu9t5v0__fill_2
* cell instance gf180mcu_fd_sc_mcu9t5v0__fill_2_127 r0 *1 0,0
Xgf180mcu_fd_sc_mcu9t5v0__fill_2_127 VDD
+ gf180mcu_fd_sc_mcu9t5v0__fill_2_127__VNW VDD VSS
+ gf180mcu_fd_sc_mcu9t5v0__fill_2
* cell instance gf180mcu_fd_sc_mcu9t5v0__fill_2_128 r0 *1 0,0
Xgf180mcu_fd_sc_mcu9t5v0__fill_2_128 VDD VSS \_063_ VSS
+ gf180mcu_fd_sc_mcu9t5v0__fill_2
* cell instance gf180mcu_fd_sc_mcu9t5v0__fill_2_129 r0 *1 0,0
Xgf180mcu_fd_sc_mcu9t5v0__fill_2_129 VDD
+ gf180mcu_fd_sc_mcu9t5v0__fill_2_129__VNW
+ gf180mcu_fd_sc_mcu9t5v0__fill_2_129__VPW VSS gf180mcu_fd_sc_mcu9t5v0__fill_2
* cell instance gf180mcu_fd_sc_mcu9t5v0__fill_2_130 r0 *1 0,0
Xgf180mcu_fd_sc_mcu9t5v0__fill_2_130 VDD
+ gf180mcu_fd_sc_mcu9t5v0__fill_2_130__VNW
+ gf180mcu_fd_sc_mcu9t5v0__fill_2_130__VPW VSS gf180mcu_fd_sc_mcu9t5v0__fill_2
* cell instance gf180mcu_fd_sc_mcu9t5v0__fill_2_131 r0 *1 0,0
Xgf180mcu_fd_sc_mcu9t5v0__fill_2_131 VDD
+ gf180mcu_fd_sc_mcu9t5v0__fill_2_131__VNW
+ gf180mcu_fd_sc_mcu9t5v0__fill_2_131__VPW VSS gf180mcu_fd_sc_mcu9t5v0__fill_2
* cell instance gf180mcu_fd_sc_mcu9t5v0__fill_2_132 r0 *1 0,0
Xgf180mcu_fd_sc_mcu9t5v0__fill_2_132 VDD VSS
+ gf180mcu_fd_sc_mcu9t5v0__fill_2_132__VPW VSS gf180mcu_fd_sc_mcu9t5v0__fill_2
* cell instance gf180mcu_fd_sc_mcu9t5v0__fill_2_133 r0 *1 0,0
Xgf180mcu_fd_sc_mcu9t5v0__fill_2_133 VDD byte_idx[1] byte_idx[1] VSS
+ gf180mcu_fd_sc_mcu9t5v0__fill_2
* cell instance gf180mcu_fd_sc_mcu9t5v0__fill_2_134 r0 *1 0,0
Xgf180mcu_fd_sc_mcu9t5v0__fill_2_134 VDD
+ gf180mcu_fd_sc_mcu9t5v0__fill_2_134__VNW
+ gf180mcu_fd_sc_mcu9t5v0__fill_2_134__VPW VSS gf180mcu_fd_sc_mcu9t5v0__fill_2
* cell instance gf180mcu_fd_sc_mcu9t5v0__fill_2_135 r0 *1 0,0
Xgf180mcu_fd_sc_mcu9t5v0__fill_2_135 VDD tx_state[2]
+ gf180mcu_fd_sc_mcu9t5v0__fill_2_135__VPW VSS gf180mcu_fd_sc_mcu9t5v0__fill_2
* cell instance gf180mcu_fd_sc_mcu9t5v0__fill_2_136 r0 *1 0,0
Xgf180mcu_fd_sc_mcu9t5v0__fill_2_136 VDD
+ gf180mcu_fd_sc_mcu9t5v0__fill_2_136__VNW
+ gf180mcu_fd_sc_mcu9t5v0__fill_2_136__VPW VSS gf180mcu_fd_sc_mcu9t5v0__fill_2
* cell instance gf180mcu_fd_sc_mcu9t5v0__fill_2_137 r0 *1 0,0
Xgf180mcu_fd_sc_mcu9t5v0__fill_2_137 VDD clknet_3_5__leaf_clk
+ gf180mcu_fd_sc_mcu9t5v0__fill_2_137__VPW VSS gf180mcu_fd_sc_mcu9t5v0__fill_2
* cell instance gf180mcu_fd_sc_mcu9t5v0__fill_2_138 r0 *1 0,0
Xgf180mcu_fd_sc_mcu9t5v0__fill_2_138 VDD VSS VSS VSS
+ gf180mcu_fd_sc_mcu9t5v0__fill_2
* cell instance gf180mcu_fd_sc_mcu9t5v0__fill_2_139 r0 *1 0,0
Xgf180mcu_fd_sc_mcu9t5v0__fill_2_139 VDD \_135_ \_065_ VSS
+ gf180mcu_fd_sc_mcu9t5v0__fill_2
* cell instance gf180mcu_fd_sc_mcu9t5v0__fill_2_140 r0 *1 0,0
Xgf180mcu_fd_sc_mcu9t5v0__fill_2_140 VDD VSS VSS VSS
+ gf180mcu_fd_sc_mcu9t5v0__fill_2
* cell instance gf180mcu_fd_sc_mcu9t5v0__fill_2_141 r0 *1 0,0
Xgf180mcu_fd_sc_mcu9t5v0__fill_2_141 VDD byte_idx[0] VSS VSS
+ gf180mcu_fd_sc_mcu9t5v0__fill_2
* cell instance gf180mcu_fd_sc_mcu9t5v0__fill_2_142 r0 *1 0,0
Xgf180mcu_fd_sc_mcu9t5v0__fill_2_142 VDD VSS VSS VSS
+ gf180mcu_fd_sc_mcu9t5v0__fill_2
* cell instance gf180mcu_fd_sc_mcu9t5v0__fill_2_143 r0 *1 0,0
Xgf180mcu_fd_sc_mcu9t5v0__fill_2_143 VDD \_098_ \_098_ VSS
+ gf180mcu_fd_sc_mcu9t5v0__fill_2
* cell instance gf180mcu_fd_sc_mcu9t5v0__fill_2_144 r0 *1 0,0
Xgf180mcu_fd_sc_mcu9t5v0__fill_2_144 VDD \_141_ \_138_ VSS
+ gf180mcu_fd_sc_mcu9t5v0__fill_2
* cell instance gf180mcu_fd_sc_mcu9t5v0__fill_2_145 r0 *1 0,0
Xgf180mcu_fd_sc_mcu9t5v0__fill_2_145 VDD VDD VDD VSS
+ gf180mcu_fd_sc_mcu9t5v0__fill_2
* cell instance gf180mcu_fd_sc_mcu9t5v0__fill_2_146 r0 *1 0,0
Xgf180mcu_fd_sc_mcu9t5v0__fill_2_146 VDD VDD VDD VSS
+ gf180mcu_fd_sc_mcu9t5v0__fill_2
* cell instance gf180mcu_fd_sc_mcu9t5v0__fill_2_147 r0 *1 0,0
Xgf180mcu_fd_sc_mcu9t5v0__fill_2_147 VDD VDD VDD VSS
+ gf180mcu_fd_sc_mcu9t5v0__fill_2
* cell instance gf180mcu_fd_sc_mcu9t5v0__fill_2_148 r0 *1 0,0
Xgf180mcu_fd_sc_mcu9t5v0__fill_2_148 VDD VDD \_066_ VSS
+ gf180mcu_fd_sc_mcu9t5v0__fill_2
* cell instance gf180mcu_fd_sc_mcu9t5v0__fill_2_149 r0 *1 0,0
Xgf180mcu_fd_sc_mcu9t5v0__fill_2_149 VDD \_094_ \_094_ VSS
+ gf180mcu_fd_sc_mcu9t5v0__fill_2
* cell instance gf180mcu_fd_sc_mcu9t5v0__fill_2_150 r0 *1 0,0
Xgf180mcu_fd_sc_mcu9t5v0__fill_2_150 VDD
+ gf180mcu_fd_sc_mcu9t5v0__fill_2_150__VNW
+ gf180mcu_fd_sc_mcu9t5v0__fill_2_150__VPW VSS gf180mcu_fd_sc_mcu9t5v0__fill_2
* cell instance gf180mcu_fd_sc_mcu9t5v0__fill_2_151 r0 *1 0,0
Xgf180mcu_fd_sc_mcu9t5v0__fill_2_151 VDD
+ gf180mcu_fd_sc_mcu9t5v0__fill_2_151__VNW
+ gf180mcu_fd_sc_mcu9t5v0__fill_2_151__VPW VSS gf180mcu_fd_sc_mcu9t5v0__fill_2
* cell instance gf180mcu_fd_sc_mcu9t5v0__fill_2_152 r0 *1 0,0
Xgf180mcu_fd_sc_mcu9t5v0__fill_2_152 VDD
+ gf180mcu_fd_sc_mcu9t5v0__fill_2_152__VNW
+ gf180mcu_fd_sc_mcu9t5v0__fill_2_152__VPW VSS gf180mcu_fd_sc_mcu9t5v0__fill_2
* cell instance gf180mcu_fd_sc_mcu9t5v0__fill_2_153 r0 *1 0,0
Xgf180mcu_fd_sc_mcu9t5v0__fill_2_153 VDD
+ gf180mcu_fd_sc_mcu9t5v0__fill_2_153__VNW
+ gf180mcu_fd_sc_mcu9t5v0__fill_2_153__VPW VSS gf180mcu_fd_sc_mcu9t5v0__fill_2
* cell instance gf180mcu_fd_sc_mcu9t5v0__fill_2_154 r0 *1 0,0
Xgf180mcu_fd_sc_mcu9t5v0__fill_2_154 VDD
+ gf180mcu_fd_sc_mcu9t5v0__fill_2_154__VNW VDD VSS
+ gf180mcu_fd_sc_mcu9t5v0__fill_2
* cell instance gf180mcu_fd_sc_mcu9t5v0__fill_2_155 r0 *1 0,0
Xgf180mcu_fd_sc_mcu9t5v0__fill_2_155 VDD
+ gf180mcu_fd_sc_mcu9t5v0__fill_2_155__VNW
+ gf180mcu_fd_sc_mcu9t5v0__fill_2_155__VPW VSS gf180mcu_fd_sc_mcu9t5v0__fill_2
* cell instance gf180mcu_fd_sc_mcu9t5v0__fill_2_156 r0 *1 0,0
Xgf180mcu_fd_sc_mcu9t5v0__fill_2_156 VDD
+ gf180mcu_fd_sc_mcu9t5v0__fill_2_156__VNW
+ gf180mcu_fd_sc_mcu9t5v0__fill_2_156__VPW VSS gf180mcu_fd_sc_mcu9t5v0__fill_2
* cell instance gf180mcu_fd_sc_mcu9t5v0__fill_2_157 r0 *1 0,0
Xgf180mcu_fd_sc_mcu9t5v0__fill_2_157 VDD VSS
+ gf180mcu_fd_sc_mcu9t5v0__fill_2_157__VPW VSS gf180mcu_fd_sc_mcu9t5v0__fill_2
* cell instance gf180mcu_fd_sc_mcu9t5v0__fill_2_158 r0 *1 0,0
Xgf180mcu_fd_sc_mcu9t5v0__fill_2_158 VDD
+ gf180mcu_fd_sc_mcu9t5v0__fill_2_158__VNW
+ gf180mcu_fd_sc_mcu9t5v0__fill_2_158__VPW VSS gf180mcu_fd_sc_mcu9t5v0__fill_2
* cell instance gf180mcu_fd_sc_mcu9t5v0__fill_2_159 r0 *1 0,0
Xgf180mcu_fd_sc_mcu9t5v0__fill_2_159 VDD
+ gf180mcu_fd_sc_mcu9t5v0__fill_2_159__VNW
+ gf180mcu_fd_sc_mcu9t5v0__fill_2_159__VPW VSS gf180mcu_fd_sc_mcu9t5v0__fill_2
* cell instance gf180mcu_fd_sc_mcu9t5v0__fill_2_160 r0 *1 0,0
Xgf180mcu_fd_sc_mcu9t5v0__fill_2_160 VDD VSS
+ gf180mcu_fd_sc_mcu9t5v0__fill_2_160__VPW VSS gf180mcu_fd_sc_mcu9t5v0__fill_2
* cell instance gf180mcu_fd_sc_mcu9t5v0__fill_2_161 r0 *1 0,0
Xgf180mcu_fd_sc_mcu9t5v0__fill_2_161 VDD
+ gf180mcu_fd_sc_mcu9t5v0__fill_2_161__VNW
+ gf180mcu_fd_sc_mcu9t5v0__fill_2_161__VPW VSS gf180mcu_fd_sc_mcu9t5v0__fill_2
* cell instance gf180mcu_fd_sc_mcu9t5v0__fill_2_162 r0 *1 0,0
Xgf180mcu_fd_sc_mcu9t5v0__fill_2_162 VDD
+ gf180mcu_fd_sc_mcu9t5v0__fill_2_162__VNW
+ gf180mcu_fd_sc_mcu9t5v0__fill_2_162__VPW VSS gf180mcu_fd_sc_mcu9t5v0__fill_2
* cell instance gf180mcu_fd_sc_mcu9t5v0__fill_2_163 r0 *1 0,0
Xgf180mcu_fd_sc_mcu9t5v0__fill_2_163 VDD
+ gf180mcu_fd_sc_mcu9t5v0__fill_2_163__VNW
+ gf180mcu_fd_sc_mcu9t5v0__fill_2_163__VPW VSS gf180mcu_fd_sc_mcu9t5v0__fill_2
* cell instance gf180mcu_fd_sc_mcu9t5v0__fill_2_164 r0 *1 0,0
Xgf180mcu_fd_sc_mcu9t5v0__fill_2_164 VDD
+ gf180mcu_fd_sc_mcu9t5v0__fill_2_164__VNW
+ gf180mcu_fd_sc_mcu9t5v0__fill_2_164__VPW VSS gf180mcu_fd_sc_mcu9t5v0__fill_2
* cell instance gf180mcu_fd_sc_mcu9t5v0__fill_2_165 r0 *1 0,0
Xgf180mcu_fd_sc_mcu9t5v0__fill_2_165 VDD
+ gf180mcu_fd_sc_mcu9t5v0__fill_2_165__VNW
+ gf180mcu_fd_sc_mcu9t5v0__fill_2_165__VPW VSS gf180mcu_fd_sc_mcu9t5v0__fill_2
* cell instance gf180mcu_fd_sc_mcu9t5v0__fill_2_166 r0 *1 0,0
Xgf180mcu_fd_sc_mcu9t5v0__fill_2_166 VDD
+ gf180mcu_fd_sc_mcu9t5v0__fill_2_166__VNW
+ gf180mcu_fd_sc_mcu9t5v0__fill_2_166__VPW VSS gf180mcu_fd_sc_mcu9t5v0__fill_2
* cell instance gf180mcu_fd_sc_mcu9t5v0__fill_32_0 r0 *1 0,0
Xgf180mcu_fd_sc_mcu9t5v0__fill_32_0 VDD gf180mcu_fd_sc_mcu9t5v0__fill_32_0__VNW
+ gf180mcu_fd_sc_mcu9t5v0__fill_32_0__VPW VSS gf180mcu_fd_sc_mcu9t5v0__fill_32
* cell instance gf180mcu_fd_sc_mcu9t5v0__fill_32_1 r0 *1 0,0
Xgf180mcu_fd_sc_mcu9t5v0__fill_32_1 VDD gf180mcu_fd_sc_mcu9t5v0__fill_32_1__VNW
+ gf180mcu_fd_sc_mcu9t5v0__fill_32_1__VPW VSS gf180mcu_fd_sc_mcu9t5v0__fill_32
* cell instance gf180mcu_fd_sc_mcu9t5v0__fill_32_2 r0 *1 0,0
Xgf180mcu_fd_sc_mcu9t5v0__fill_32_2 VDD gf180mcu_fd_sc_mcu9t5v0__fill_32_2__VNW
+ gf180mcu_fd_sc_mcu9t5v0__fill_32_2__VPW VSS gf180mcu_fd_sc_mcu9t5v0__fill_32
* cell instance gf180mcu_fd_sc_mcu9t5v0__fill_32_3 r0 *1 0,0
Xgf180mcu_fd_sc_mcu9t5v0__fill_32_3 VDD gf180mcu_fd_sc_mcu9t5v0__fill_32_3__VNW
+ gf180mcu_fd_sc_mcu9t5v0__fill_32_3__VPW VSS gf180mcu_fd_sc_mcu9t5v0__fill_32
* cell instance gf180mcu_fd_sc_mcu9t5v0__fill_32_4 r0 *1 0,0
Xgf180mcu_fd_sc_mcu9t5v0__fill_32_4 VDD gf180mcu_fd_sc_mcu9t5v0__fill_32_4__VNW
+ gf180mcu_fd_sc_mcu9t5v0__fill_32_4__VPW VSS gf180mcu_fd_sc_mcu9t5v0__fill_32
* cell instance gf180mcu_fd_sc_mcu9t5v0__fill_32_5 r0 *1 0,0
Xgf180mcu_fd_sc_mcu9t5v0__fill_32_5 VDD gf180mcu_fd_sc_mcu9t5v0__fill_32_5__VNW
+ gf180mcu_fd_sc_mcu9t5v0__fill_32_5__VPW VSS gf180mcu_fd_sc_mcu9t5v0__fill_32
* cell instance gf180mcu_fd_sc_mcu9t5v0__fill_32_6 r0 *1 0,0
Xgf180mcu_fd_sc_mcu9t5v0__fill_32_6 VDD gf180mcu_fd_sc_mcu9t5v0__fill_32_6__VNW
+ gf180mcu_fd_sc_mcu9t5v0__fill_32_6__VPW VSS gf180mcu_fd_sc_mcu9t5v0__fill_32
* cell instance gf180mcu_fd_sc_mcu9t5v0__fill_32_7 r0 *1 0,0
Xgf180mcu_fd_sc_mcu9t5v0__fill_32_7 VDD gf180mcu_fd_sc_mcu9t5v0__fill_32_7__VNW
+ gf180mcu_fd_sc_mcu9t5v0__fill_32_7__VPW VSS gf180mcu_fd_sc_mcu9t5v0__fill_32
* cell instance gf180mcu_fd_sc_mcu9t5v0__fill_32_8 r0 *1 0,0
Xgf180mcu_fd_sc_mcu9t5v0__fill_32_8 VDD gf180mcu_fd_sc_mcu9t5v0__fill_32_8__VNW
+ gf180mcu_fd_sc_mcu9t5v0__fill_32_8__VPW VSS gf180mcu_fd_sc_mcu9t5v0__fill_32
* cell instance gf180mcu_fd_sc_mcu9t5v0__fill_32_9 r0 *1 0,0
Xgf180mcu_fd_sc_mcu9t5v0__fill_32_9 VDD VSS VSS VSS
+ gf180mcu_fd_sc_mcu9t5v0__fill_32
* cell instance gf180mcu_fd_sc_mcu9t5v0__fill_32_10 r0 *1 0,0
Xgf180mcu_fd_sc_mcu9t5v0__fill_32_10 VDD
+ gf180mcu_fd_sc_mcu9t5v0__fill_32_10__VNW
+ gf180mcu_fd_sc_mcu9t5v0__fill_32_10__VPW VSS gf180mcu_fd_sc_mcu9t5v0__fill_32
* cell instance gf180mcu_fd_sc_mcu9t5v0__fill_32_11 r0 *1 0,0
Xgf180mcu_fd_sc_mcu9t5v0__fill_32_11 VDD
+ gf180mcu_fd_sc_mcu9t5v0__fill_32_11__VNW
+ gf180mcu_fd_sc_mcu9t5v0__fill_32_11__VPW VSS gf180mcu_fd_sc_mcu9t5v0__fill_32
* cell instance gf180mcu_fd_sc_mcu9t5v0__fill_32_12 r0 *1 0,0
Xgf180mcu_fd_sc_mcu9t5v0__fill_32_12 VDD
+ gf180mcu_fd_sc_mcu9t5v0__fill_32_12__VNW
+ gf180mcu_fd_sc_mcu9t5v0__fill_32_12__VPW VSS gf180mcu_fd_sc_mcu9t5v0__fill_32
* cell instance gf180mcu_fd_sc_mcu9t5v0__fill_32_13 r0 *1 0,0
Xgf180mcu_fd_sc_mcu9t5v0__fill_32_13 VDD
+ gf180mcu_fd_sc_mcu9t5v0__fill_32_13__VNW
+ gf180mcu_fd_sc_mcu9t5v0__fill_32_13__VPW VSS gf180mcu_fd_sc_mcu9t5v0__fill_32
* cell instance gf180mcu_fd_sc_mcu9t5v0__fill_32_14 r0 *1 0,0
Xgf180mcu_fd_sc_mcu9t5v0__fill_32_14 VDD
+ gf180mcu_fd_sc_mcu9t5v0__fill_32_14__VNW
+ gf180mcu_fd_sc_mcu9t5v0__fill_32_14__VPW VSS gf180mcu_fd_sc_mcu9t5v0__fill_32
* cell instance gf180mcu_fd_sc_mcu9t5v0__fill_32_15 r0 *1 0,0
Xgf180mcu_fd_sc_mcu9t5v0__fill_32_15 VDD
+ gf180mcu_fd_sc_mcu9t5v0__fill_32_15__VNW
+ gf180mcu_fd_sc_mcu9t5v0__fill_32_15__VPW VSS gf180mcu_fd_sc_mcu9t5v0__fill_32
* cell instance gf180mcu_fd_sc_mcu9t5v0__fill_32_16 r0 *1 0,0
Xgf180mcu_fd_sc_mcu9t5v0__fill_32_16 VDD
+ gf180mcu_fd_sc_mcu9t5v0__fill_32_16__VNW
+ gf180mcu_fd_sc_mcu9t5v0__fill_32_16__VPW VSS gf180mcu_fd_sc_mcu9t5v0__fill_32
* cell instance gf180mcu_fd_sc_mcu9t5v0__fill_32_17 r0 *1 0,0
Xgf180mcu_fd_sc_mcu9t5v0__fill_32_17 VDD
+ gf180mcu_fd_sc_mcu9t5v0__fill_32_17__VNW
+ gf180mcu_fd_sc_mcu9t5v0__fill_32_17__VPW VSS gf180mcu_fd_sc_mcu9t5v0__fill_32
* cell instance gf180mcu_fd_sc_mcu9t5v0__fill_32_18 r0 *1 0,0
Xgf180mcu_fd_sc_mcu9t5v0__fill_32_18 VDD VDD VDD VSS
+ gf180mcu_fd_sc_mcu9t5v0__fill_32
* cell instance gf180mcu_fd_sc_mcu9t5v0__fill_32_19 r0 *1 0,0
Xgf180mcu_fd_sc_mcu9t5v0__fill_32_19 VDD VDD VDD VSS
+ gf180mcu_fd_sc_mcu9t5v0__fill_32
* cell instance gf180mcu_fd_sc_mcu9t5v0__fill_32_20 r0 *1 0,0
Xgf180mcu_fd_sc_mcu9t5v0__fill_32_20 VDD VDD VDD VSS
+ gf180mcu_fd_sc_mcu9t5v0__fill_32
* cell instance gf180mcu_fd_sc_mcu9t5v0__fill_32_21 r0 *1 0,0
Xgf180mcu_fd_sc_mcu9t5v0__fill_32_21 VDD
+ gf180mcu_fd_sc_mcu9t5v0__fill_32_21__VNW
+ gf180mcu_fd_sc_mcu9t5v0__fill_32_21__VPW VSS gf180mcu_fd_sc_mcu9t5v0__fill_32
* cell instance gf180mcu_fd_sc_mcu9t5v0__fill_32_22 r0 *1 0,0
Xgf180mcu_fd_sc_mcu9t5v0__fill_32_22 VDD
+ gf180mcu_fd_sc_mcu9t5v0__fill_32_22__VNW
+ gf180mcu_fd_sc_mcu9t5v0__fill_32_22__VPW VSS gf180mcu_fd_sc_mcu9t5v0__fill_32
* cell instance gf180mcu_fd_sc_mcu9t5v0__fill_32_23 r0 *1 0,0
Xgf180mcu_fd_sc_mcu9t5v0__fill_32_23 VDD
+ gf180mcu_fd_sc_mcu9t5v0__fill_32_23__VNW
+ gf180mcu_fd_sc_mcu9t5v0__fill_32_23__VPW VSS gf180mcu_fd_sc_mcu9t5v0__fill_32
* cell instance gf180mcu_fd_sc_mcu9t5v0__fill_32_24 r0 *1 0,0
Xgf180mcu_fd_sc_mcu9t5v0__fill_32_24 VDD
+ gf180mcu_fd_sc_mcu9t5v0__fill_32_24__VNW
+ gf180mcu_fd_sc_mcu9t5v0__fill_32_24__VPW VSS gf180mcu_fd_sc_mcu9t5v0__fill_32
* cell instance gf180mcu_fd_sc_mcu9t5v0__fill_4_0 r0 *1 0,0
Xgf180mcu_fd_sc_mcu9t5v0__fill_4_0 VDD gf180mcu_fd_sc_mcu9t5v0__fill_4_0__VNW
+ gf180mcu_fd_sc_mcu9t5v0__fill_4_0__VPW VSS gf180mcu_fd_sc_mcu9t5v0__fill_4
* cell instance gf180mcu_fd_sc_mcu9t5v0__fill_4_1 r0 *1 0,0
Xgf180mcu_fd_sc_mcu9t5v0__fill_4_1 VDD gf180mcu_fd_sc_mcu9t5v0__fill_4_1__VNW
+ gf180mcu_fd_sc_mcu9t5v0__fill_4_1__VPW VSS gf180mcu_fd_sc_mcu9t5v0__fill_4
* cell instance gf180mcu_fd_sc_mcu9t5v0__fill_4_2 r0 *1 0,0
Xgf180mcu_fd_sc_mcu9t5v0__fill_4_2 VDD gf180mcu_fd_sc_mcu9t5v0__fill_4_2__VNW
+ gf180mcu_fd_sc_mcu9t5v0__fill_4_2__VPW VSS gf180mcu_fd_sc_mcu9t5v0__fill_4
* cell instance gf180mcu_fd_sc_mcu9t5v0__fill_4_3 r0 *1 0,0
Xgf180mcu_fd_sc_mcu9t5v0__fill_4_3 VDD gf180mcu_fd_sc_mcu9t5v0__fill_4_3__VNW
+ gf180mcu_fd_sc_mcu9t5v0__fill_4_3__VPW VSS gf180mcu_fd_sc_mcu9t5v0__fill_4
* cell instance gf180mcu_fd_sc_mcu9t5v0__fill_4_4 r0 *1 0,0
Xgf180mcu_fd_sc_mcu9t5v0__fill_4_4 VDD gf180mcu_fd_sc_mcu9t5v0__fill_4_4__VNW
+ gf180mcu_fd_sc_mcu9t5v0__fill_4_4__VPW VSS gf180mcu_fd_sc_mcu9t5v0__fill_4
* cell instance gf180mcu_fd_sc_mcu9t5v0__fill_4_5 r0 *1 0,0
Xgf180mcu_fd_sc_mcu9t5v0__fill_4_5 VDD VSS
+ gf180mcu_fd_sc_mcu9t5v0__fill_4_5__VPW VSS gf180mcu_fd_sc_mcu9t5v0__fill_4
* cell instance gf180mcu_fd_sc_mcu9t5v0__fill_4_6 r0 *1 0,0
Xgf180mcu_fd_sc_mcu9t5v0__fill_4_6 VDD gf180mcu_fd_sc_mcu9t5v0__fill_4_6__VNW
+ gf180mcu_fd_sc_mcu9t5v0__fill_4_6__VPW VSS gf180mcu_fd_sc_mcu9t5v0__fill_4
* cell instance gf180mcu_fd_sc_mcu9t5v0__fill_4_7 r0 *1 0,0
Xgf180mcu_fd_sc_mcu9t5v0__fill_4_7 VDD gf180mcu_fd_sc_mcu9t5v0__fill_4_7__VNW
+ VDD VSS gf180mcu_fd_sc_mcu9t5v0__fill_4
* cell instance gf180mcu_fd_sc_mcu9t5v0__fill_4_8 r0 *1 0,0
Xgf180mcu_fd_sc_mcu9t5v0__fill_4_8 VDD gf180mcu_fd_sc_mcu9t5v0__fill_4_8__VNW
+ VDD VSS gf180mcu_fd_sc_mcu9t5v0__fill_4
* cell instance gf180mcu_fd_sc_mcu9t5v0__fill_4_9 r0 *1 0,0
Xgf180mcu_fd_sc_mcu9t5v0__fill_4_9 VDD gf180mcu_fd_sc_mcu9t5v0__fill_4_9__VNW
+ VDD VSS gf180mcu_fd_sc_mcu9t5v0__fill_4
* cell instance gf180mcu_fd_sc_mcu9t5v0__fill_4_10 r0 *1 0,0
Xgf180mcu_fd_sc_mcu9t5v0__fill_4_10 VDD gf180mcu_fd_sc_mcu9t5v0__fill_4_10__VNW
+ gf180mcu_fd_sc_mcu9t5v0__fill_4_10__VPW VSS gf180mcu_fd_sc_mcu9t5v0__fill_4
* cell instance gf180mcu_fd_sc_mcu9t5v0__fill_4_11 r0 *1 0,0
Xgf180mcu_fd_sc_mcu9t5v0__fill_4_11 VDD VSS
+ gf180mcu_fd_sc_mcu9t5v0__fill_4_11__VPW VSS gf180mcu_fd_sc_mcu9t5v0__fill_4
* cell instance gf180mcu_fd_sc_mcu9t5v0__fill_4_12 r0 *1 0,0
Xgf180mcu_fd_sc_mcu9t5v0__fill_4_12 VDD VSS VSS VSS
+ gf180mcu_fd_sc_mcu9t5v0__fill_4
* cell instance gf180mcu_fd_sc_mcu9t5v0__fill_4_13 r0 *1 0,0
Xgf180mcu_fd_sc_mcu9t5v0__fill_4_13 VDD VSS VSS VSS
+ gf180mcu_fd_sc_mcu9t5v0__fill_4
* cell instance gf180mcu_fd_sc_mcu9t5v0__fill_4_14 r0 *1 0,0
Xgf180mcu_fd_sc_mcu9t5v0__fill_4_14 VDD VSS VSS VSS
+ gf180mcu_fd_sc_mcu9t5v0__fill_4
* cell instance gf180mcu_fd_sc_mcu9t5v0__fill_4_15 r0 *1 0,0
Xgf180mcu_fd_sc_mcu9t5v0__fill_4_15 VDD VDD VDD VSS
+ gf180mcu_fd_sc_mcu9t5v0__fill_4
* cell instance gf180mcu_fd_sc_mcu9t5v0__fill_4_16 r0 *1 0,0
Xgf180mcu_fd_sc_mcu9t5v0__fill_4_16 VDD VDD VDD VSS
+ gf180mcu_fd_sc_mcu9t5v0__fill_4
* cell instance gf180mcu_fd_sc_mcu9t5v0__fill_4_17 r0 *1 0,0
Xgf180mcu_fd_sc_mcu9t5v0__fill_4_17 VDD VDD VDD VSS
+ gf180mcu_fd_sc_mcu9t5v0__fill_4
* cell instance gf180mcu_fd_sc_mcu9t5v0__fill_4_18 r0 *1 0,0
Xgf180mcu_fd_sc_mcu9t5v0__fill_4_18 VDD VDD VDD VSS
+ gf180mcu_fd_sc_mcu9t5v0__fill_4
* cell instance gf180mcu_fd_sc_mcu9t5v0__fill_4_19 r0 *1 0,0
Xgf180mcu_fd_sc_mcu9t5v0__fill_4_19 VDD u_destuffer/_00_ u_destuffer/_00_ VSS
+ gf180mcu_fd_sc_mcu9t5v0__fill_4
* cell instance gf180mcu_fd_sc_mcu9t5v0__fill_4_20 r0 *1 0,0
Xgf180mcu_fd_sc_mcu9t5v0__fill_4_20 VDD VDD VDD VSS
+ gf180mcu_fd_sc_mcu9t5v0__fill_4
* cell instance gf180mcu_fd_sc_mcu9t5v0__fill_4_21 r0 *1 0,0
Xgf180mcu_fd_sc_mcu9t5v0__fill_4_21 VDD \_002_
+ gf180mcu_fd_sc_mcu9t5v0__fill_4_21__VPW VSS gf180mcu_fd_sc_mcu9t5v0__fill_4
* cell instance gf180mcu_fd_sc_mcu9t5v0__fill_4_22 r0 *1 0,0
Xgf180mcu_fd_sc_mcu9t5v0__fill_4_22 VDD gf180mcu_fd_sc_mcu9t5v0__fill_4_22__VNW
+ gf180mcu_fd_sc_mcu9t5v0__fill_4_22__VPW VSS gf180mcu_fd_sc_mcu9t5v0__fill_4
* cell instance gf180mcu_fd_sc_mcu9t5v0__fill_4_23 r0 *1 0,0
Xgf180mcu_fd_sc_mcu9t5v0__fill_4_23 VDD gf180mcu_fd_sc_mcu9t5v0__fill_4_23__VNW
+ gf180mcu_fd_sc_mcu9t5v0__fill_4_23__VPW VSS gf180mcu_fd_sc_mcu9t5v0__fill_4
* cell instance gf180mcu_fd_sc_mcu9t5v0__fill_4_24 r0 *1 0,0
Xgf180mcu_fd_sc_mcu9t5v0__fill_4_24 VDD \_125_
+ gf180mcu_fd_sc_mcu9t5v0__fill_4_24__VPW VSS gf180mcu_fd_sc_mcu9t5v0__fill_4
* cell instance gf180mcu_fd_sc_mcu9t5v0__fill_4_25 r0 *1 0,0
Xgf180mcu_fd_sc_mcu9t5v0__fill_4_25 VDD gf180mcu_fd_sc_mcu9t5v0__fill_4_25__VNW
+ gf180mcu_fd_sc_mcu9t5v0__fill_4_25__VPW VSS gf180mcu_fd_sc_mcu9t5v0__fill_4
* cell instance gf180mcu_fd_sc_mcu9t5v0__fill_4_26 r0 *1 0,0
Xgf180mcu_fd_sc_mcu9t5v0__fill_4_26 VDD gf180mcu_fd_sc_mcu9t5v0__fill_4_26__VNW
+ gf180mcu_fd_sc_mcu9t5v0__fill_4_26__VPW VSS gf180mcu_fd_sc_mcu9t5v0__fill_4
* cell instance gf180mcu_fd_sc_mcu9t5v0__fill_4_27 r0 *1 0,0
Xgf180mcu_fd_sc_mcu9t5v0__fill_4_27 VDD VSS
+ gf180mcu_fd_sc_mcu9t5v0__fill_4_27__VPW VSS gf180mcu_fd_sc_mcu9t5v0__fill_4
* cell instance gf180mcu_fd_sc_mcu9t5v0__fill_4_28 r0 *1 0,0
Xgf180mcu_fd_sc_mcu9t5v0__fill_4_28 VDD \_112_ \_112_ VSS
+ gf180mcu_fd_sc_mcu9t5v0__fill_4
* cell instance gf180mcu_fd_sc_mcu9t5v0__fill_4_29 r0 *1 0,0
Xgf180mcu_fd_sc_mcu9t5v0__fill_4_29 VDD gf180mcu_fd_sc_mcu9t5v0__fill_4_29__VNW
+ gf180mcu_fd_sc_mcu9t5v0__fill_4_29__VPW VSS gf180mcu_fd_sc_mcu9t5v0__fill_4
* cell instance gf180mcu_fd_sc_mcu9t5v0__fill_4_30 r0 *1 0,0
Xgf180mcu_fd_sc_mcu9t5v0__fill_4_30 VDD gf180mcu_fd_sc_mcu9t5v0__fill_4_30__VNW
+ gf180mcu_fd_sc_mcu9t5v0__fill_4_30__VPW VSS gf180mcu_fd_sc_mcu9t5v0__fill_4
* cell instance gf180mcu_fd_sc_mcu9t5v0__fill_4_31 r0 *1 0,0
Xgf180mcu_fd_sc_mcu9t5v0__fill_4_31 VDD gf180mcu_fd_sc_mcu9t5v0__fill_4_31__VNW
+ gf180mcu_fd_sc_mcu9t5v0__fill_4_31__VPW VSS gf180mcu_fd_sc_mcu9t5v0__fill_4
* cell instance gf180mcu_fd_sc_mcu9t5v0__fill_4_32 r0 *1 0,0
Xgf180mcu_fd_sc_mcu9t5v0__fill_4_32 VDD DataIn[2]
+ gf180mcu_fd_sc_mcu9t5v0__fill_4_32__VPW VSS gf180mcu_fd_sc_mcu9t5v0__fill_4
* cell instance gf180mcu_fd_sc_mcu9t5v0__fill_4_33 r0 *1 0,0
Xgf180mcu_fd_sc_mcu9t5v0__fill_4_33 VDD gf180mcu_fd_sc_mcu9t5v0__fill_4_33__VNW
+ gf180mcu_fd_sc_mcu9t5v0__fill_4_33__VPW VSS gf180mcu_fd_sc_mcu9t5v0__fill_4
* cell instance gf180mcu_fd_sc_mcu9t5v0__fill_4_34 r0 *1 0,0
Xgf180mcu_fd_sc_mcu9t5v0__fill_4_34 VDD gf180mcu_fd_sc_mcu9t5v0__fill_4_34__VNW
+ gf180mcu_fd_sc_mcu9t5v0__fill_4_34__VPW VSS gf180mcu_fd_sc_mcu9t5v0__fill_4
* cell instance gf180mcu_fd_sc_mcu9t5v0__fill_4_35 r0 *1 0,0
Xgf180mcu_fd_sc_mcu9t5v0__fill_4_35 VDD gf180mcu_fd_sc_mcu9t5v0__fill_4_35__VNW
+ rx_shift[2] VSS gf180mcu_fd_sc_mcu9t5v0__fill_4
* cell instance gf180mcu_fd_sc_mcu9t5v0__fill_4_36 r0 *1 0,0
Xgf180mcu_fd_sc_mcu9t5v0__fill_4_36 VDD gf180mcu_fd_sc_mcu9t5v0__fill_4_36__VNW
+ VDD VSS gf180mcu_fd_sc_mcu9t5v0__fill_4
* cell instance gf180mcu_fd_sc_mcu9t5v0__fill_4_37 r0 *1 0,0
Xgf180mcu_fd_sc_mcu9t5v0__fill_4_37 VDD gf180mcu_fd_sc_mcu9t5v0__fill_4_37__VNW
+ gf180mcu_fd_sc_mcu9t5v0__fill_4_37__VPW VSS gf180mcu_fd_sc_mcu9t5v0__fill_4
* cell instance gf180mcu_fd_sc_mcu9t5v0__fill_4_38 r0 *1 0,0
Xgf180mcu_fd_sc_mcu9t5v0__fill_4_38 VDD gf180mcu_fd_sc_mcu9t5v0__fill_4_38__VNW
+ gf180mcu_fd_sc_mcu9t5v0__fill_4_38__VPW VSS gf180mcu_fd_sc_mcu9t5v0__fill_4
* cell instance gf180mcu_fd_sc_mcu9t5v0__fill_4_39 r0 *1 0,0
Xgf180mcu_fd_sc_mcu9t5v0__fill_4_39 VDD gf180mcu_fd_sc_mcu9t5v0__fill_4_39__VNW
+ VDD VSS gf180mcu_fd_sc_mcu9t5v0__fill_4
* cell instance gf180mcu_fd_sc_mcu9t5v0__fill_4_40 r0 *1 0,0
Xgf180mcu_fd_sc_mcu9t5v0__fill_4_40 VDD gf180mcu_fd_sc_mcu9t5v0__fill_4_40__VNW
+ gf180mcu_fd_sc_mcu9t5v0__fill_4_40__VPW VSS gf180mcu_fd_sc_mcu9t5v0__fill_4
* cell instance gf180mcu_fd_sc_mcu9t5v0__fill_4_41 r0 *1 0,0
Xgf180mcu_fd_sc_mcu9t5v0__fill_4_41 VDD gf180mcu_fd_sc_mcu9t5v0__fill_4_41__VNW
+ gf180mcu_fd_sc_mcu9t5v0__fill_4_41__VPW VSS gf180mcu_fd_sc_mcu9t5v0__fill_4
* cell instance gf180mcu_fd_sc_mcu9t5v0__fill_4_42 r0 *1 0,0
Xgf180mcu_fd_sc_mcu9t5v0__fill_4_42 VDD gf180mcu_fd_sc_mcu9t5v0__fill_4_42__VNW
+ gf180mcu_fd_sc_mcu9t5v0__fill_4_42__VPW VSS gf180mcu_fd_sc_mcu9t5v0__fill_4
* cell instance gf180mcu_fd_sc_mcu9t5v0__fill_4_43 r0 *1 0,0
Xgf180mcu_fd_sc_mcu9t5v0__fill_4_43 VDD gf180mcu_fd_sc_mcu9t5v0__fill_4_43__VNW
+ VDD VSS gf180mcu_fd_sc_mcu9t5v0__fill_4
* cell instance gf180mcu_fd_sc_mcu9t5v0__fill_4_44 r0 *1 0,0
Xgf180mcu_fd_sc_mcu9t5v0__fill_4_44 VDD VSS VSS VSS
+ gf180mcu_fd_sc_mcu9t5v0__fill_4
* cell instance gf180mcu_fd_sc_mcu9t5v0__fill_4_45 r0 *1 0,0
Xgf180mcu_fd_sc_mcu9t5v0__fill_4_45 VDD VSS VSS VSS
+ gf180mcu_fd_sc_mcu9t5v0__fill_4
* cell instance gf180mcu_fd_sc_mcu9t5v0__fill_4_46 r0 *1 0,0
Xgf180mcu_fd_sc_mcu9t5v0__fill_4_46 VDD VSS VSS VSS
+ gf180mcu_fd_sc_mcu9t5v0__fill_4
* cell instance gf180mcu_fd_sc_mcu9t5v0__fill_4_47 r0 *1 0,0
Xgf180mcu_fd_sc_mcu9t5v0__fill_4_47 VDD VSS VSS VSS
+ gf180mcu_fd_sc_mcu9t5v0__fill_4
* cell instance gf180mcu_fd_sc_mcu9t5v0__fill_4_48 r0 *1 0,0
Xgf180mcu_fd_sc_mcu9t5v0__fill_4_48 VDD RxError RxError VSS
+ gf180mcu_fd_sc_mcu9t5v0__fill_4
* cell instance gf180mcu_fd_sc_mcu9t5v0__fill_4_49 r0 *1 0,0
Xgf180mcu_fd_sc_mcu9t5v0__fill_4_49 VDD VDD VDD VSS
+ gf180mcu_fd_sc_mcu9t5v0__fill_4
* cell instance gf180mcu_fd_sc_mcu9t5v0__fill_4_50 r0 *1 0,0
Xgf180mcu_fd_sc_mcu9t5v0__fill_4_50 VDD VDD VDD VSS
+ gf180mcu_fd_sc_mcu9t5v0__fill_4
* cell instance gf180mcu_fd_sc_mcu9t5v0__fill_4_51 r0 *1 0,0
Xgf180mcu_fd_sc_mcu9t5v0__fill_4_51 VDD gf180mcu_fd_sc_mcu9t5v0__fill_4_51__VNW
+ gf180mcu_fd_sc_mcu9t5v0__fill_4_51__VPW VSS gf180mcu_fd_sc_mcu9t5v0__fill_4
* cell instance gf180mcu_fd_sc_mcu9t5v0__fill_4_52 r0 *1 0,0
Xgf180mcu_fd_sc_mcu9t5v0__fill_4_52 VDD gf180mcu_fd_sc_mcu9t5v0__fill_4_52__VNW
+ gf180mcu_fd_sc_mcu9t5v0__fill_4_52__VPW VSS gf180mcu_fd_sc_mcu9t5v0__fill_4
* cell instance gf180mcu_fd_sc_mcu9t5v0__fill_4_53 r0 *1 0,0
Xgf180mcu_fd_sc_mcu9t5v0__fill_4_53 VDD gf180mcu_fd_sc_mcu9t5v0__fill_4_53__VNW
+ gf180mcu_fd_sc_mcu9t5v0__fill_4_53__VPW VSS gf180mcu_fd_sc_mcu9t5v0__fill_4
* cell instance gf180mcu_fd_sc_mcu9t5v0__fill_4_54 r0 *1 0,0
Xgf180mcu_fd_sc_mcu9t5v0__fill_4_54 VDD gf180mcu_fd_sc_mcu9t5v0__fill_4_54__VNW
+ gf180mcu_fd_sc_mcu9t5v0__fill_4_54__VPW VSS gf180mcu_fd_sc_mcu9t5v0__fill_4
* cell instance gf180mcu_fd_sc_mcu9t5v0__fill_4_55 r0 *1 0,0
Xgf180mcu_fd_sc_mcu9t5v0__fill_4_55 VDD gf180mcu_fd_sc_mcu9t5v0__fill_4_55__VNW
+ gf180mcu_fd_sc_mcu9t5v0__fill_4_55__VPW VSS gf180mcu_fd_sc_mcu9t5v0__fill_4
* cell instance gf180mcu_fd_sc_mcu9t5v0__fill_4_56 r0 *1 0,0
Xgf180mcu_fd_sc_mcu9t5v0__fill_4_56 VDD gf180mcu_fd_sc_mcu9t5v0__fill_4_56__VNW
+ gf180mcu_fd_sc_mcu9t5v0__fill_4_56__VPW VSS gf180mcu_fd_sc_mcu9t5v0__fill_4
* cell instance gf180mcu_fd_sc_mcu9t5v0__fill_4_57 r0 *1 0,0
Xgf180mcu_fd_sc_mcu9t5v0__fill_4_57 VDD gf180mcu_fd_sc_mcu9t5v0__fill_4_57__VNW
+ gf180mcu_fd_sc_mcu9t5v0__fill_4_57__VPW VSS gf180mcu_fd_sc_mcu9t5v0__fill_4
* cell instance gf180mcu_fd_sc_mcu9t5v0__fill_4_58 r0 *1 0,0
Xgf180mcu_fd_sc_mcu9t5v0__fill_4_58 VDD DataIn[2]
+ gf180mcu_fd_sc_mcu9t5v0__fill_4_58__VPW VSS gf180mcu_fd_sc_mcu9t5v0__fill_4
* cell instance gf180mcu_fd_sc_mcu9t5v0__fill_4_59 r0 *1 0,0
Xgf180mcu_fd_sc_mcu9t5v0__fill_4_59 VDD gf180mcu_fd_sc_mcu9t5v0__fill_4_59__VNW
+ gf180mcu_fd_sc_mcu9t5v0__fill_4_59__VPW VSS gf180mcu_fd_sc_mcu9t5v0__fill_4
* cell instance gf180mcu_fd_sc_mcu9t5v0__fill_4_60 r0 *1 0,0
Xgf180mcu_fd_sc_mcu9t5v0__fill_4_60 VDD gf180mcu_fd_sc_mcu9t5v0__fill_4_60__VNW
+ gf180mcu_fd_sc_mcu9t5v0__fill_4_60__VPW VSS gf180mcu_fd_sc_mcu9t5v0__fill_4
* cell instance gf180mcu_fd_sc_mcu9t5v0__fill_4_61 r0 *1 0,0
Xgf180mcu_fd_sc_mcu9t5v0__fill_4_61 VDD VSS
+ gf180mcu_fd_sc_mcu9t5v0__fill_4_61__VPW VSS gf180mcu_fd_sc_mcu9t5v0__fill_4
* cell instance gf180mcu_fd_sc_mcu9t5v0__fill_4_62 r0 *1 0,0
Xgf180mcu_fd_sc_mcu9t5v0__fill_4_62 VDD gf180mcu_fd_sc_mcu9t5v0__fill_4_62__VNW
+ gf180mcu_fd_sc_mcu9t5v0__fill_4_62__VPW VSS gf180mcu_fd_sc_mcu9t5v0__fill_4
* cell instance gf180mcu_fd_sc_mcu9t5v0__fill_4_63 r0 *1 0,0
Xgf180mcu_fd_sc_mcu9t5v0__fill_4_63 VDD byte_reg[7] \_153_ VSS
+ gf180mcu_fd_sc_mcu9t5v0__fill_4
* cell instance gf180mcu_fd_sc_mcu9t5v0__fill_4_64 r0 *1 0,0
Xgf180mcu_fd_sc_mcu9t5v0__fill_4_64 VDD \_054_ \_054_ VSS
+ gf180mcu_fd_sc_mcu9t5v0__fill_4
* cell instance gf180mcu_fd_sc_mcu9t5v0__fill_4_65 r0 *1 0,0
Xgf180mcu_fd_sc_mcu9t5v0__fill_4_65 VDD gf180mcu_fd_sc_mcu9t5v0__fill_4_65__VNW
+ \_054_ VSS gf180mcu_fd_sc_mcu9t5v0__fill_4
* cell instance gf180mcu_fd_sc_mcu9t5v0__fill_4_66 r0 *1 0,0
Xgf180mcu_fd_sc_mcu9t5v0__fill_4_66 VDD gf180mcu_fd_sc_mcu9t5v0__fill_4_66__VNW
+ gf180mcu_fd_sc_mcu9t5v0__fill_4_66__VPW VSS gf180mcu_fd_sc_mcu9t5v0__fill_4
* cell instance gf180mcu_fd_sc_mcu9t5v0__fill_4_67 r0 *1 0,0
Xgf180mcu_fd_sc_mcu9t5v0__fill_4_67 VDD gf180mcu_fd_sc_mcu9t5v0__fill_4_67__VNW
+ \_102_ VSS gf180mcu_fd_sc_mcu9t5v0__fill_4
* cell instance gf180mcu_fd_sc_mcu9t5v0__fill_4_68 r0 *1 0,0
Xgf180mcu_fd_sc_mcu9t5v0__fill_4_68 VDD gf180mcu_fd_sc_mcu9t5v0__fill_4_68__VNW
+ gf180mcu_fd_sc_mcu9t5v0__fill_4_68__VPW VSS gf180mcu_fd_sc_mcu9t5v0__fill_4
* cell instance gf180mcu_fd_sc_mcu9t5v0__fill_4_69 r0 *1 0,0
Xgf180mcu_fd_sc_mcu9t5v0__fill_4_69 VDD gf180mcu_fd_sc_mcu9t5v0__fill_4_69__VNW
+ gf180mcu_fd_sc_mcu9t5v0__fill_4_69__VPW VSS gf180mcu_fd_sc_mcu9t5v0__fill_4
* cell instance gf180mcu_fd_sc_mcu9t5v0__fill_4_70 r0 *1 0,0
Xgf180mcu_fd_sc_mcu9t5v0__fill_4_70 VDD gf180mcu_fd_sc_mcu9t5v0__fill_4_70__VNW
+ gf180mcu_fd_sc_mcu9t5v0__fill_4_70__VPW VSS gf180mcu_fd_sc_mcu9t5v0__fill_4
* cell instance gf180mcu_fd_sc_mcu9t5v0__fill_4_71 r0 *1 0,0
Xgf180mcu_fd_sc_mcu9t5v0__fill_4_71 VDD u_eop_detector/_15_ u_eop_detector/_15_
+ VSS gf180mcu_fd_sc_mcu9t5v0__fill_4
* cell instance gf180mcu_fd_sc_mcu9t5v0__fill_4_72 r0 *1 0,0
Xgf180mcu_fd_sc_mcu9t5v0__fill_4_72 VDD u_stuffer/_00_ u_stuffer/_00_ VSS
+ gf180mcu_fd_sc_mcu9t5v0__fill_4
* cell instance gf180mcu_fd_sc_mcu9t5v0__fill_4_73 r0 *1 0,0
Xgf180mcu_fd_sc_mcu9t5v0__fill_4_73 VDD line_state[0]
+ gf180mcu_fd_sc_mcu9t5v0__fill_4_73__VPW VSS gf180mcu_fd_sc_mcu9t5v0__fill_4
* cell instance gf180mcu_fd_sc_mcu9t5v0__fill_4_74 r0 *1 0,0
Xgf180mcu_fd_sc_mcu9t5v0__fill_4_74 VDD gf180mcu_fd_sc_mcu9t5v0__fill_4_74__VNW
+ gf180mcu_fd_sc_mcu9t5v0__fill_4_74__VPW VSS gf180mcu_fd_sc_mcu9t5v0__fill_4
* cell instance gf180mcu_fd_sc_mcu9t5v0__fill_4_75 r0 *1 0,0
Xgf180mcu_fd_sc_mcu9t5v0__fill_4_75 VDD gf180mcu_fd_sc_mcu9t5v0__fill_4_75__VNW
+ gf180mcu_fd_sc_mcu9t5v0__fill_4_75__VPW VSS gf180mcu_fd_sc_mcu9t5v0__fill_4
* cell instance gf180mcu_fd_sc_mcu9t5v0__fill_4_76 r0 *1 0,0
Xgf180mcu_fd_sc_mcu9t5v0__fill_4_76 VDD gf180mcu_fd_sc_mcu9t5v0__fill_4_76__VNW
+ gf180mcu_fd_sc_mcu9t5v0__fill_4_76__VPW VSS gf180mcu_fd_sc_mcu9t5v0__fill_4
* cell instance gf180mcu_fd_sc_mcu9t5v0__fill_4_77 r0 *1 0,0
Xgf180mcu_fd_sc_mcu9t5v0__fill_4_77 VDD gf180mcu_fd_sc_mcu9t5v0__fill_4_77__VNW
+ gf180mcu_fd_sc_mcu9t5v0__fill_4_77__VPW VSS gf180mcu_fd_sc_mcu9t5v0__fill_4
* cell instance gf180mcu_fd_sc_mcu9t5v0__fill_4_78 r0 *1 0,0
Xgf180mcu_fd_sc_mcu9t5v0__fill_4_78 VDD gf180mcu_fd_sc_mcu9t5v0__fill_4_78__VNW
+ gf180mcu_fd_sc_mcu9t5v0__fill_4_78__VPW VSS gf180mcu_fd_sc_mcu9t5v0__fill_4
* cell instance gf180mcu_fd_sc_mcu9t5v0__fill_4_79 r0 *1 0,0
Xgf180mcu_fd_sc_mcu9t5v0__fill_4_79 VDD txdp txdp VSS
+ gf180mcu_fd_sc_mcu9t5v0__fill_4
* cell instance gf180mcu_fd_sc_mcu9t5v0__fill_4_80 r0 *1 0,0
Xgf180mcu_fd_sc_mcu9t5v0__fill_4_80 VDD u_encoder/_1_ u_encoder/_1_ VSS
+ gf180mcu_fd_sc_mcu9t5v0__fill_4
* cell instance gf180mcu_fd_sc_mcu9t5v0__fill_4_81 r0 *1 0,0
Xgf180mcu_fd_sc_mcu9t5v0__fill_4_81 VDD gf180mcu_fd_sc_mcu9t5v0__fill_4_81__VNW
+ gf180mcu_fd_sc_mcu9t5v0__fill_4_81__VPW VSS gf180mcu_fd_sc_mcu9t5v0__fill_4
* cell instance gf180mcu_fd_sc_mcu9t5v0__fill_4_82 r0 *1 0,0
Xgf180mcu_fd_sc_mcu9t5v0__fill_4_82 VDD u_eop_detector/_03_
+ gf180mcu_fd_sc_mcu9t5v0__fill_4_82__VPW VSS gf180mcu_fd_sc_mcu9t5v0__fill_4
* cell instance gf180mcu_fd_sc_mcu9t5v0__fill_4_83 r0 *1 0,0
Xgf180mcu_fd_sc_mcu9t5v0__fill_4_83 VDD u_eop_detector/_03_ u_eop_detector/_03_
+ VSS gf180mcu_fd_sc_mcu9t5v0__fill_4
* cell instance gf180mcu_fd_sc_mcu9t5v0__fill_4_84 r0 *1 0,0
Xgf180mcu_fd_sc_mcu9t5v0__fill_4_84 VDD gf180mcu_fd_sc_mcu9t5v0__fill_4_84__VNW
+ gf180mcu_fd_sc_mcu9t5v0__fill_4_84__VPW VSS gf180mcu_fd_sc_mcu9t5v0__fill_4
* cell instance gf180mcu_fd_sc_mcu9t5v0__fill_4_85 r0 *1 0,0
Xgf180mcu_fd_sc_mcu9t5v0__fill_4_85 VDD gf180mcu_fd_sc_mcu9t5v0__fill_4_85__VNW
+ gf180mcu_fd_sc_mcu9t5v0__fill_4_85__VPW VSS gf180mcu_fd_sc_mcu9t5v0__fill_4
* cell instance gf180mcu_fd_sc_mcu9t5v0__fill_4_86 r0 *1 0,0
Xgf180mcu_fd_sc_mcu9t5v0__fill_4_86 VDD gf180mcu_fd_sc_mcu9t5v0__fill_4_86__VNW
+ u_stuffer/_08_ VSS gf180mcu_fd_sc_mcu9t5v0__fill_4
* cell instance gf180mcu_fd_sc_mcu9t5v0__fill_4_87 r0 *1 0,0
Xgf180mcu_fd_sc_mcu9t5v0__fill_4_87 VDD gf180mcu_fd_sc_mcu9t5v0__fill_4_87__VNW
+ gf180mcu_fd_sc_mcu9t5v0__fill_4_87__VPW VSS gf180mcu_fd_sc_mcu9t5v0__fill_4
* cell instance gf180mcu_fd_sc_mcu9t5v0__fill_4_88 r0 *1 0,0
Xgf180mcu_fd_sc_mcu9t5v0__fill_4_88 VDD VSS byte_reg[3] VSS
+ gf180mcu_fd_sc_mcu9t5v0__fill_4
* cell instance gf180mcu_fd_sc_mcu9t5v0__fill_4_89 r0 *1 0,0
Xgf180mcu_fd_sc_mcu9t5v0__fill_4_89 VDD \_077_ VSS VSS
+ gf180mcu_fd_sc_mcu9t5v0__fill_4
* cell instance gf180mcu_fd_sc_mcu9t5v0__fill_4_90 r0 *1 0,0
Xgf180mcu_fd_sc_mcu9t5v0__fill_4_90 VDD u_stuffer/_04_ VSS VSS
+ gf180mcu_fd_sc_mcu9t5v0__fill_4
* cell instance gf180mcu_fd_sc_mcu9t5v0__fill_4_91 r0 *1 0,0
Xgf180mcu_fd_sc_mcu9t5v0__fill_4_91 VDD gf180mcu_fd_sc_mcu9t5v0__fill_4_91__VNW
+ gf180mcu_fd_sc_mcu9t5v0__fill_4_91__VPW VSS gf180mcu_fd_sc_mcu9t5v0__fill_4
* cell instance gf180mcu_fd_sc_mcu9t5v0__fill_4_92 r0 *1 0,0
Xgf180mcu_fd_sc_mcu9t5v0__fill_4_92 VDD gf180mcu_fd_sc_mcu9t5v0__fill_4_92__VNW
+ gf180mcu_fd_sc_mcu9t5v0__fill_4_92__VPW VSS gf180mcu_fd_sc_mcu9t5v0__fill_4
* cell instance gf180mcu_fd_sc_mcu9t5v0__fill_4_93 r0 *1 0,0
Xgf180mcu_fd_sc_mcu9t5v0__fill_4_93 VDD gf180mcu_fd_sc_mcu9t5v0__fill_4_93__VNW
+ gf180mcu_fd_sc_mcu9t5v0__fill_4_93__VPW VSS gf180mcu_fd_sc_mcu9t5v0__fill_4
* cell instance gf180mcu_fd_sc_mcu9t5v0__fill_4_94 r0 *1 0,0
Xgf180mcu_fd_sc_mcu9t5v0__fill_4_94 VDD gf180mcu_fd_sc_mcu9t5v0__fill_4_94__VNW
+ VDD VSS gf180mcu_fd_sc_mcu9t5v0__fill_4
* cell instance gf180mcu_fd_sc_mcu9t5v0__fill_4_95 r0 *1 0,0
Xgf180mcu_fd_sc_mcu9t5v0__fill_4_95 VDD gf180mcu_fd_sc_mcu9t5v0__fill_4_95__VNW
+ gf180mcu_fd_sc_mcu9t5v0__fill_4_95__VPW VSS gf180mcu_fd_sc_mcu9t5v0__fill_4
* cell instance gf180mcu_fd_sc_mcu9t5v0__fill_4_96 r0 *1 0,0
Xgf180mcu_fd_sc_mcu9t5v0__fill_4_96 VDD gf180mcu_fd_sc_mcu9t5v0__fill_4_96__VNW
+ gf180mcu_fd_sc_mcu9t5v0__fill_4_96__VPW VSS gf180mcu_fd_sc_mcu9t5v0__fill_4
* cell instance gf180mcu_fd_sc_mcu9t5v0__fill_4_97 r0 *1 0,0
Xgf180mcu_fd_sc_mcu9t5v0__fill_4_97 VDD gf180mcu_fd_sc_mcu9t5v0__fill_4_97__VNW
+ VDD VSS gf180mcu_fd_sc_mcu9t5v0__fill_4
* cell instance gf180mcu_fd_sc_mcu9t5v0__fill_4_98 r0 *1 0,0
Xgf180mcu_fd_sc_mcu9t5v0__fill_4_98 VDD gf180mcu_fd_sc_mcu9t5v0__fill_4_98__VNW
+ gf180mcu_fd_sc_mcu9t5v0__fill_4_98__VPW VSS gf180mcu_fd_sc_mcu9t5v0__fill_4
* cell instance gf180mcu_fd_sc_mcu9t5v0__fill_4_99 r0 *1 0,0
Xgf180mcu_fd_sc_mcu9t5v0__fill_4_99 VDD clknet_3_5__leaf_clk
+ gf180mcu_fd_sc_mcu9t5v0__fill_4_99__VPW VSS gf180mcu_fd_sc_mcu9t5v0__fill_4
* cell instance gf180mcu_fd_sc_mcu9t5v0__fill_4_100 r0 *1 0,0
Xgf180mcu_fd_sc_mcu9t5v0__fill_4_100 VDD \_065_ \_065_ VSS
+ gf180mcu_fd_sc_mcu9t5v0__fill_4
* cell instance gf180mcu_fd_sc_mcu9t5v0__fill_4_101 r0 *1 0,0
Xgf180mcu_fd_sc_mcu9t5v0__fill_4_101 VDD
+ gf180mcu_fd_sc_mcu9t5v0__fill_4_101__VNW
+ gf180mcu_fd_sc_mcu9t5v0__fill_4_101__VPW VSS gf180mcu_fd_sc_mcu9t5v0__fill_4
* cell instance gf180mcu_fd_sc_mcu9t5v0__fill_4_102 r0 *1 0,0
Xgf180mcu_fd_sc_mcu9t5v0__fill_4_102 VDD \_077_
+ gf180mcu_fd_sc_mcu9t5v0__fill_4_102__VPW VSS gf180mcu_fd_sc_mcu9t5v0__fill_4
* cell instance gf180mcu_fd_sc_mcu9t5v0__fill_4_103 r0 *1 0,0
Xgf180mcu_fd_sc_mcu9t5v0__fill_4_103 VDD
+ gf180mcu_fd_sc_mcu9t5v0__fill_4_103__VNW
+ gf180mcu_fd_sc_mcu9t5v0__fill_4_103__VPW VSS gf180mcu_fd_sc_mcu9t5v0__fill_4
* cell instance gf180mcu_fd_sc_mcu9t5v0__fill_4_104 r0 *1 0,0
Xgf180mcu_fd_sc_mcu9t5v0__fill_4_104 VDD
+ gf180mcu_fd_sc_mcu9t5v0__fill_4_104__VNW
+ gf180mcu_fd_sc_mcu9t5v0__fill_4_104__VPW VSS gf180mcu_fd_sc_mcu9t5v0__fill_4
* cell instance gf180mcu_fd_sc_mcu9t5v0__fill_4_105 r0 *1 0,0
Xgf180mcu_fd_sc_mcu9t5v0__fill_4_105 VDD
+ gf180mcu_fd_sc_mcu9t5v0__fill_4_105__VNW
+ gf180mcu_fd_sc_mcu9t5v0__fill_4_105__VPW VSS gf180mcu_fd_sc_mcu9t5v0__fill_4
* cell instance gf180mcu_fd_sc_mcu9t5v0__fill_4_106 r0 *1 0,0
Xgf180mcu_fd_sc_mcu9t5v0__fill_4_106 VDD
+ gf180mcu_fd_sc_mcu9t5v0__fill_4_106__VNW
+ gf180mcu_fd_sc_mcu9t5v0__fill_4_106__VPW VSS gf180mcu_fd_sc_mcu9t5v0__fill_4
* cell instance gf180mcu_fd_sc_mcu9t5v0__fill_4_107 r0 *1 0,0
Xgf180mcu_fd_sc_mcu9t5v0__fill_4_107 VDD
+ gf180mcu_fd_sc_mcu9t5v0__fill_4_107__VNW
+ gf180mcu_fd_sc_mcu9t5v0__fill_4_107__VPW VSS gf180mcu_fd_sc_mcu9t5v0__fill_4
* cell instance gf180mcu_fd_sc_mcu9t5v0__fill_4_108 r0 *1 0,0
Xgf180mcu_fd_sc_mcu9t5v0__fill_4_108 VDD tx_state[1] tx_state[1] VSS
+ gf180mcu_fd_sc_mcu9t5v0__fill_4
* cell instance gf180mcu_fd_sc_mcu9t5v0__fill_4_109 r0 *1 0,0
Xgf180mcu_fd_sc_mcu9t5v0__fill_4_109 VDD
+ gf180mcu_fd_sc_mcu9t5v0__fill_4_109__VNW \_060_ VSS
+ gf180mcu_fd_sc_mcu9t5v0__fill_4
* cell instance gf180mcu_fd_sc_mcu9t5v0__fill_4_110 r0 *1 0,0
Xgf180mcu_fd_sc_mcu9t5v0__fill_4_110 VDD
+ gf180mcu_fd_sc_mcu9t5v0__fill_4_110__VNW
+ gf180mcu_fd_sc_mcu9t5v0__fill_4_110__VPW VSS gf180mcu_fd_sc_mcu9t5v0__fill_4
* cell instance gf180mcu_fd_sc_mcu9t5v0__fill_4_111 r0 *1 0,0
Xgf180mcu_fd_sc_mcu9t5v0__fill_4_111 VDD
+ gf180mcu_fd_sc_mcu9t5v0__fill_4_111__VNW
+ gf180mcu_fd_sc_mcu9t5v0__fill_4_111__VPW VSS gf180mcu_fd_sc_mcu9t5v0__fill_4
* cell instance gf180mcu_fd_sc_mcu9t5v0__fill_4_112 r0 *1 0,0
Xgf180mcu_fd_sc_mcu9t5v0__fill_4_112 VDD
+ gf180mcu_fd_sc_mcu9t5v0__fill_4_112__VNW
+ gf180mcu_fd_sc_mcu9t5v0__fill_4_112__VPW VSS gf180mcu_fd_sc_mcu9t5v0__fill_4
* cell instance gf180mcu_fd_sc_mcu9t5v0__fill_4_113 r0 *1 0,0
Xgf180mcu_fd_sc_mcu9t5v0__fill_4_113 VDD \_084_ \_084_ VSS
+ gf180mcu_fd_sc_mcu9t5v0__fill_4
* cell instance gf180mcu_fd_sc_mcu9t5v0__fill_4_114 r0 *1 0,0
Xgf180mcu_fd_sc_mcu9t5v0__fill_4_114 VDD \_084_ \_084_ VSS
+ gf180mcu_fd_sc_mcu9t5v0__fill_4
* cell instance gf180mcu_fd_sc_mcu9t5v0__fill_4_115 r0 *1 0,0
Xgf180mcu_fd_sc_mcu9t5v0__fill_4_115 VDD VSS VSS VSS
+ gf180mcu_fd_sc_mcu9t5v0__fill_4
* cell instance gf180mcu_fd_sc_mcu9t5v0__fill_4_116 r0 *1 0,0
Xgf180mcu_fd_sc_mcu9t5v0__fill_4_116 VDD VSS VSS VSS
+ gf180mcu_fd_sc_mcu9t5v0__fill_4
* cell instance gf180mcu_fd_sc_mcu9t5v0__fill_4_117 r0 *1 0,0
Xgf180mcu_fd_sc_mcu9t5v0__fill_4_117 VDD \_111_ VSS VSS
+ gf180mcu_fd_sc_mcu9t5v0__fill_4
* cell instance gf180mcu_fd_sc_mcu9t5v0__fill_4_118 r0 *1 0,0
Xgf180mcu_fd_sc_mcu9t5v0__fill_4_118 VDD \_111_ \_111_ VSS
+ gf180mcu_fd_sc_mcu9t5v0__fill_4
* cell instance gf180mcu_fd_sc_mcu9t5v0__fill_4_119 r0 *1 0,0
Xgf180mcu_fd_sc_mcu9t5v0__fill_4_119 VDD VSS VSS VSS
+ gf180mcu_fd_sc_mcu9t5v0__fill_4
* cell instance gf180mcu_fd_sc_mcu9t5v0__fill_4_120 r0 *1 0,0
Xgf180mcu_fd_sc_mcu9t5v0__fill_4_120 VDD VDD VDD VSS
+ gf180mcu_fd_sc_mcu9t5v0__fill_4
* cell instance gf180mcu_fd_sc_mcu9t5v0__fill_4_121 r0 *1 0,0
Xgf180mcu_fd_sc_mcu9t5v0__fill_4_121 VDD VDD VDD VSS
+ gf180mcu_fd_sc_mcu9t5v0__fill_4
* cell instance gf180mcu_fd_sc_mcu9t5v0__fill_4_122 r0 *1 0,0
Xgf180mcu_fd_sc_mcu9t5v0__fill_4_122 VDD
+ gf180mcu_fd_sc_mcu9t5v0__fill_4_122__VNW
+ gf180mcu_fd_sc_mcu9t5v0__fill_4_122__VPW VSS gf180mcu_fd_sc_mcu9t5v0__fill_4
* cell instance gf180mcu_fd_sc_mcu9t5v0__fill_4_123 r0 *1 0,0
Xgf180mcu_fd_sc_mcu9t5v0__fill_4_123 VDD
+ gf180mcu_fd_sc_mcu9t5v0__fill_4_123__VNW
+ gf180mcu_fd_sc_mcu9t5v0__fill_4_123__VPW VSS gf180mcu_fd_sc_mcu9t5v0__fill_4
* cell instance gf180mcu_fd_sc_mcu9t5v0__fill_4_124 r0 *1 0,0
Xgf180mcu_fd_sc_mcu9t5v0__fill_4_124 VDD
+ gf180mcu_fd_sc_mcu9t5v0__fill_4_124__VNW
+ gf180mcu_fd_sc_mcu9t5v0__fill_4_124__VPW VSS gf180mcu_fd_sc_mcu9t5v0__fill_4
* cell instance gf180mcu_fd_sc_mcu9t5v0__fill_4_125 r0 *1 0,0
Xgf180mcu_fd_sc_mcu9t5v0__fill_4_125 VDD
+ gf180mcu_fd_sc_mcu9t5v0__fill_4_125__VNW VDD VSS
+ gf180mcu_fd_sc_mcu9t5v0__fill_4
* cell instance gf180mcu_fd_sc_mcu9t5v0__fill_4_126 r0 *1 0,0
Xgf180mcu_fd_sc_mcu9t5v0__fill_4_126 VDD VSS
+ gf180mcu_fd_sc_mcu9t5v0__fill_4_126__VPW VSS gf180mcu_fd_sc_mcu9t5v0__fill_4
* cell instance gf180mcu_fd_sc_mcu9t5v0__fill_4_127 r0 *1 0,0
Xgf180mcu_fd_sc_mcu9t5v0__fill_4_127 VDD
+ gf180mcu_fd_sc_mcu9t5v0__fill_4_127__VNW
+ gf180mcu_fd_sc_mcu9t5v0__fill_4_127__VPW VSS gf180mcu_fd_sc_mcu9t5v0__fill_4
* cell instance gf180mcu_fd_sc_mcu9t5v0__fill_4_128 r0 *1 0,0
Xgf180mcu_fd_sc_mcu9t5v0__fill_4_128 VDD VSS
+ gf180mcu_fd_sc_mcu9t5v0__fill_4_128__VPW VSS gf180mcu_fd_sc_mcu9t5v0__fill_4
* cell instance gf180mcu_fd_sc_mcu9t5v0__fill_4_129 r0 *1 0,0
Xgf180mcu_fd_sc_mcu9t5v0__fill_4_129 VDD
+ gf180mcu_fd_sc_mcu9t5v0__fill_4_129__VNW
+ gf180mcu_fd_sc_mcu9t5v0__fill_4_129__VPW VSS gf180mcu_fd_sc_mcu9t5v0__fill_4
* cell instance gf180mcu_fd_sc_mcu9t5v0__fill_4_130 r0 *1 0,0
Xgf180mcu_fd_sc_mcu9t5v0__fill_4_130 VDD
+ gf180mcu_fd_sc_mcu9t5v0__fill_4_130__VNW
+ gf180mcu_fd_sc_mcu9t5v0__fill_4_130__VPW VSS gf180mcu_fd_sc_mcu9t5v0__fill_4
* cell instance gf180mcu_fd_sc_mcu9t5v0__fill_4_131 r0 *1 0,0
Xgf180mcu_fd_sc_mcu9t5v0__fill_4_131 VDD
+ gf180mcu_fd_sc_mcu9t5v0__fill_4_131__VNW
+ gf180mcu_fd_sc_mcu9t5v0__fill_4_131__VPW VSS gf180mcu_fd_sc_mcu9t5v0__fill_4
* cell instance gf180mcu_fd_sc_mcu9t5v0__fill_4_132 r0 *1 0,0
Xgf180mcu_fd_sc_mcu9t5v0__fill_4_132 VDD
+ gf180mcu_fd_sc_mcu9t5v0__fill_4_132__VNW
+ gf180mcu_fd_sc_mcu9t5v0__fill_4_132__VPW VSS gf180mcu_fd_sc_mcu9t5v0__fill_4
* cell instance gf180mcu_fd_sc_mcu9t5v0__fill_4_133 r0 *1 0,0
Xgf180mcu_fd_sc_mcu9t5v0__fill_4_133 VDD
+ gf180mcu_fd_sc_mcu9t5v0__fill_4_133__VNW
+ gf180mcu_fd_sc_mcu9t5v0__fill_4_133__VPW VSS gf180mcu_fd_sc_mcu9t5v0__fill_4
* cell instance gf180mcu_fd_sc_mcu9t5v0__fill_4_134 r0 *1 0,0
Xgf180mcu_fd_sc_mcu9t5v0__fill_4_134 VDD
+ gf180mcu_fd_sc_mcu9t5v0__fill_4_134__VNW
+ gf180mcu_fd_sc_mcu9t5v0__fill_4_134__VPW VSS gf180mcu_fd_sc_mcu9t5v0__fill_4
* cell instance gf180mcu_fd_sc_mcu9t5v0__fill_4_135 r0 *1 0,0
Xgf180mcu_fd_sc_mcu9t5v0__fill_4_135 VDD
+ gf180mcu_fd_sc_mcu9t5v0__fill_4_135__VNW VDD VSS
+ gf180mcu_fd_sc_mcu9t5v0__fill_4
* cell instance gf180mcu_fd_sc_mcu9t5v0__fill_4_136 r0 *1 0,0
Xgf180mcu_fd_sc_mcu9t5v0__fill_4_136 VDD
+ gf180mcu_fd_sc_mcu9t5v0__fill_4_136__VNW
+ gf180mcu_fd_sc_mcu9t5v0__fill_4_136__VPW VSS gf180mcu_fd_sc_mcu9t5v0__fill_4
* cell instance gf180mcu_fd_sc_mcu9t5v0__fill_64_0 r0 *1 0,0
Xgf180mcu_fd_sc_mcu9t5v0__fill_64_0 VDD gf180mcu_fd_sc_mcu9t5v0__fill_64_0__VNW
+ gf180mcu_fd_sc_mcu9t5v0__fill_64_0__VPW VSS gf180mcu_fd_sc_mcu9t5v0__fill_64
* cell instance gf180mcu_fd_sc_mcu9t5v0__fill_64_1 r0 *1 0,0
Xgf180mcu_fd_sc_mcu9t5v0__fill_64_1 VDD gf180mcu_fd_sc_mcu9t5v0__fill_64_1__VNW
+ gf180mcu_fd_sc_mcu9t5v0__fill_64_1__VPW VSS gf180mcu_fd_sc_mcu9t5v0__fill_64
* cell instance gf180mcu_fd_sc_mcu9t5v0__fill_64_2 r0 *1 0,0
Xgf180mcu_fd_sc_mcu9t5v0__fill_64_2 VDD VSS
+ gf180mcu_fd_sc_mcu9t5v0__fill_64_2__VPW VSS gf180mcu_fd_sc_mcu9t5v0__fill_64
* cell instance gf180mcu_fd_sc_mcu9t5v0__fill_64_3 r0 *1 0,0
Xgf180mcu_fd_sc_mcu9t5v0__fill_64_3 VDD gf180mcu_fd_sc_mcu9t5v0__fill_64_3__VNW
+ gf180mcu_fd_sc_mcu9t5v0__fill_64_3__VPW VSS gf180mcu_fd_sc_mcu9t5v0__fill_64
* cell instance gf180mcu_fd_sc_mcu9t5v0__fill_64_4 r0 *1 0,0
Xgf180mcu_fd_sc_mcu9t5v0__fill_64_4 VDD gf180mcu_fd_sc_mcu9t5v0__fill_64_4__VNW
+ gf180mcu_fd_sc_mcu9t5v0__fill_64_4__VPW VSS gf180mcu_fd_sc_mcu9t5v0__fill_64
* cell instance gf180mcu_fd_sc_mcu9t5v0__fill_64_5 r0 *1 0,0
Xgf180mcu_fd_sc_mcu9t5v0__fill_64_5 VDD gf180mcu_fd_sc_mcu9t5v0__fill_64_5__VNW
+ gf180mcu_fd_sc_mcu9t5v0__fill_64_5__VPW VSS gf180mcu_fd_sc_mcu9t5v0__fill_64
* cell instance gf180mcu_fd_sc_mcu9t5v0__fill_64_6 r0 *1 0,0
Xgf180mcu_fd_sc_mcu9t5v0__fill_64_6 VDD gf180mcu_fd_sc_mcu9t5v0__fill_64_6__VNW
+ gf180mcu_fd_sc_mcu9t5v0__fill_64_6__VPW VSS gf180mcu_fd_sc_mcu9t5v0__fill_64
* cell instance gf180mcu_fd_sc_mcu9t5v0__fill_64_7 r0 *1 0,0
Xgf180mcu_fd_sc_mcu9t5v0__fill_64_7 VDD gf180mcu_fd_sc_mcu9t5v0__fill_64_7__VNW
+ gf180mcu_fd_sc_mcu9t5v0__fill_64_7__VPW VSS gf180mcu_fd_sc_mcu9t5v0__fill_64
* cell instance gf180mcu_fd_sc_mcu9t5v0__fill_64_8 r0 *1 0,0
Xgf180mcu_fd_sc_mcu9t5v0__fill_64_8 VDD gf180mcu_fd_sc_mcu9t5v0__fill_64_8__VNW
+ gf180mcu_fd_sc_mcu9t5v0__fill_64_8__VPW VSS gf180mcu_fd_sc_mcu9t5v0__fill_64
* cell instance gf180mcu_fd_sc_mcu9t5v0__fill_64_9 r0 *1 0,0
Xgf180mcu_fd_sc_mcu9t5v0__fill_64_9 VDD gf180mcu_fd_sc_mcu9t5v0__fill_64_9__VNW
+ gf180mcu_fd_sc_mcu9t5v0__fill_64_9__VPW VSS gf180mcu_fd_sc_mcu9t5v0__fill_64
* cell instance gf180mcu_fd_sc_mcu9t5v0__fill_64_10 r0 *1 0,0
Xgf180mcu_fd_sc_mcu9t5v0__fill_64_10 VDD
+ gf180mcu_fd_sc_mcu9t5v0__fill_64_10__VNW
+ gf180mcu_fd_sc_mcu9t5v0__fill_64_10__VPW VSS gf180mcu_fd_sc_mcu9t5v0__fill_64
* cell instance gf180mcu_fd_sc_mcu9t5v0__fill_64_11 r0 *1 0,0
Xgf180mcu_fd_sc_mcu9t5v0__fill_64_11 VDD
+ gf180mcu_fd_sc_mcu9t5v0__fill_64_11__VNW
+ gf180mcu_fd_sc_mcu9t5v0__fill_64_11__VPW VSS gf180mcu_fd_sc_mcu9t5v0__fill_64
* cell instance gf180mcu_fd_sc_mcu9t5v0__fill_64_12 r0 *1 0,0
Xgf180mcu_fd_sc_mcu9t5v0__fill_64_12 VDD
+ gf180mcu_fd_sc_mcu9t5v0__fill_64_12__VNW
+ gf180mcu_fd_sc_mcu9t5v0__fill_64_12__VPW VSS gf180mcu_fd_sc_mcu9t5v0__fill_64
* cell instance gf180mcu_fd_sc_mcu9t5v0__fill_64_13 r0 *1 0,0
Xgf180mcu_fd_sc_mcu9t5v0__fill_64_13 VDD
+ gf180mcu_fd_sc_mcu9t5v0__fill_64_13__VNW
+ gf180mcu_fd_sc_mcu9t5v0__fill_64_13__VPW VSS gf180mcu_fd_sc_mcu9t5v0__fill_64
* cell instance gf180mcu_fd_sc_mcu9t5v0__fill_64_14 r0 *1 0,0
Xgf180mcu_fd_sc_mcu9t5v0__fill_64_14 VDD
+ gf180mcu_fd_sc_mcu9t5v0__fill_64_14__VNW
+ gf180mcu_fd_sc_mcu9t5v0__fill_64_14__VPW VSS gf180mcu_fd_sc_mcu9t5v0__fill_64
* cell instance gf180mcu_fd_sc_mcu9t5v0__fill_64_15 r0 *1 0,0
Xgf180mcu_fd_sc_mcu9t5v0__fill_64_15 VDD
+ gf180mcu_fd_sc_mcu9t5v0__fill_64_15__VNW
+ gf180mcu_fd_sc_mcu9t5v0__fill_64_15__VPW VSS gf180mcu_fd_sc_mcu9t5v0__fill_64
* cell instance gf180mcu_fd_sc_mcu9t5v0__fill_64_16 r0 *1 0,0
Xgf180mcu_fd_sc_mcu9t5v0__fill_64_16 VDD
+ gf180mcu_fd_sc_mcu9t5v0__fill_64_16__VNW
+ gf180mcu_fd_sc_mcu9t5v0__fill_64_16__VPW VSS gf180mcu_fd_sc_mcu9t5v0__fill_64
* cell instance gf180mcu_fd_sc_mcu9t5v0__fill_64_17 r0 *1 0,0
Xgf180mcu_fd_sc_mcu9t5v0__fill_64_17 VDD
+ gf180mcu_fd_sc_mcu9t5v0__fill_64_17__VNW
+ gf180mcu_fd_sc_mcu9t5v0__fill_64_17__VPW VSS gf180mcu_fd_sc_mcu9t5v0__fill_64
* cell instance gf180mcu_fd_sc_mcu9t5v0__fill_64_18 r0 *1 0,0
Xgf180mcu_fd_sc_mcu9t5v0__fill_64_18 VDD VDD VDD VSS
+ gf180mcu_fd_sc_mcu9t5v0__fill_64
* cell instance gf180mcu_fd_sc_mcu9t5v0__fill_64_19 r0 *1 0,0
Xgf180mcu_fd_sc_mcu9t5v0__fill_64_19 VDD VDD VDD VSS
+ gf180mcu_fd_sc_mcu9t5v0__fill_64
* cell instance gf180mcu_fd_sc_mcu9t5v0__fill_64_20 r0 *1 0,0
Xgf180mcu_fd_sc_mcu9t5v0__fill_64_20 VDD VDD VDD VSS
+ gf180mcu_fd_sc_mcu9t5v0__fill_64
* cell instance gf180mcu_fd_sc_mcu9t5v0__fill_64_21 r0 *1 0,0
Xgf180mcu_fd_sc_mcu9t5v0__fill_64_21 VDD
+ gf180mcu_fd_sc_mcu9t5v0__fill_64_21__VNW
+ gf180mcu_fd_sc_mcu9t5v0__fill_64_21__VPW VSS gf180mcu_fd_sc_mcu9t5v0__fill_64
* cell instance gf180mcu_fd_sc_mcu9t5v0__fill_64_22 r0 *1 0,0
Xgf180mcu_fd_sc_mcu9t5v0__fill_64_22 VDD
+ gf180mcu_fd_sc_mcu9t5v0__fill_64_22__VNW
+ gf180mcu_fd_sc_mcu9t5v0__fill_64_22__VPW VSS gf180mcu_fd_sc_mcu9t5v0__fill_64
* cell instance gf180mcu_fd_sc_mcu9t5v0__fill_64_23 r0 *1 0,0
Xgf180mcu_fd_sc_mcu9t5v0__fill_64_23 VDD
+ gf180mcu_fd_sc_mcu9t5v0__fill_64_23__VNW
+ gf180mcu_fd_sc_mcu9t5v0__fill_64_23__VPW VSS gf180mcu_fd_sc_mcu9t5v0__fill_64
* cell instance gf180mcu_fd_sc_mcu9t5v0__fill_64_24 r0 *1 0,0
Xgf180mcu_fd_sc_mcu9t5v0__fill_64_24 VDD
+ gf180mcu_fd_sc_mcu9t5v0__fill_64_24__VNW
+ gf180mcu_fd_sc_mcu9t5v0__fill_64_24__VPW VSS gf180mcu_fd_sc_mcu9t5v0__fill_64
* cell instance gf180mcu_fd_sc_mcu9t5v0__fill_64_25 r0 *1 0,0
Xgf180mcu_fd_sc_mcu9t5v0__fill_64_25 VDD
+ gf180mcu_fd_sc_mcu9t5v0__fill_64_25__VNW
+ gf180mcu_fd_sc_mcu9t5v0__fill_64_25__VPW VSS gf180mcu_fd_sc_mcu9t5v0__fill_64
* cell instance gf180mcu_fd_sc_mcu9t5v0__fill_64_26 r0 *1 0,0
Xgf180mcu_fd_sc_mcu9t5v0__fill_64_26 VDD
+ gf180mcu_fd_sc_mcu9t5v0__fill_64_26__VNW
+ gf180mcu_fd_sc_mcu9t5v0__fill_64_26__VPW VSS gf180mcu_fd_sc_mcu9t5v0__fill_64
* cell instance gf180mcu_fd_sc_mcu9t5v0__fill_64_27 r0 *1 0,0
Xgf180mcu_fd_sc_mcu9t5v0__fill_64_27 VDD VSS
+ gf180mcu_fd_sc_mcu9t5v0__fill_64_27__VPW VSS gf180mcu_fd_sc_mcu9t5v0__fill_64
* cell instance gf180mcu_fd_sc_mcu9t5v0__fill_64_28 r0 *1 0,0
Xgf180mcu_fd_sc_mcu9t5v0__fill_64_28 VDD
+ gf180mcu_fd_sc_mcu9t5v0__fill_64_28__VNW
+ gf180mcu_fd_sc_mcu9t5v0__fill_64_28__VPW VSS gf180mcu_fd_sc_mcu9t5v0__fill_64
* cell instance gf180mcu_fd_sc_mcu9t5v0__fill_64_29 r0 *1 0,0
Xgf180mcu_fd_sc_mcu9t5v0__fill_64_29 VDD VSS VSS VSS
+ gf180mcu_fd_sc_mcu9t5v0__fill_64
* cell instance gf180mcu_fd_sc_mcu9t5v0__fill_64_30 r0 *1 0,0
Xgf180mcu_fd_sc_mcu9t5v0__fill_64_30 VDD VSS VSS VSS
+ gf180mcu_fd_sc_mcu9t5v0__fill_64
* cell instance gf180mcu_fd_sc_mcu9t5v0__fill_64_31 r0 *1 0,0
Xgf180mcu_fd_sc_mcu9t5v0__fill_64_31 VDD
+ gf180mcu_fd_sc_mcu9t5v0__fill_64_31__VNW
+ gf180mcu_fd_sc_mcu9t5v0__fill_64_31__VPW VSS gf180mcu_fd_sc_mcu9t5v0__fill_64
* cell instance gf180mcu_fd_sc_mcu9t5v0__fill_64_32 r0 *1 0,0
Xgf180mcu_fd_sc_mcu9t5v0__fill_64_32 VDD VSS VSS VSS
+ gf180mcu_fd_sc_mcu9t5v0__fill_64
* cell instance gf180mcu_fd_sc_mcu9t5v0__fill_8_0 r0 *1 0,0
Xgf180mcu_fd_sc_mcu9t5v0__fill_8_0 VDD gf180mcu_fd_sc_mcu9t5v0__fill_8_0__VNW
+ gf180mcu_fd_sc_mcu9t5v0__fill_8_0__VPW VSS gf180mcu_fd_sc_mcu9t5v0__fill_8
* cell instance gf180mcu_fd_sc_mcu9t5v0__fill_8_1 r0 *1 0,0
Xgf180mcu_fd_sc_mcu9t5v0__fill_8_1 VDD gf180mcu_fd_sc_mcu9t5v0__fill_8_1__VNW
+ gf180mcu_fd_sc_mcu9t5v0__fill_8_1__VPW VSS gf180mcu_fd_sc_mcu9t5v0__fill_8
* cell instance gf180mcu_fd_sc_mcu9t5v0__fill_8_2 r0 *1 0,0
Xgf180mcu_fd_sc_mcu9t5v0__fill_8_2 VDD gf180mcu_fd_sc_mcu9t5v0__fill_8_2__VNW
+ gf180mcu_fd_sc_mcu9t5v0__fill_8_2__VPW VSS gf180mcu_fd_sc_mcu9t5v0__fill_8
* cell instance gf180mcu_fd_sc_mcu9t5v0__fill_8_3 r0 *1 0,0
Xgf180mcu_fd_sc_mcu9t5v0__fill_8_3 VDD VSS
+ gf180mcu_fd_sc_mcu9t5v0__fill_8_3__VPW VSS gf180mcu_fd_sc_mcu9t5v0__fill_8
* cell instance gf180mcu_fd_sc_mcu9t5v0__fill_8_4 r0 *1 0,0
Xgf180mcu_fd_sc_mcu9t5v0__fill_8_4 VDD gf180mcu_fd_sc_mcu9t5v0__fill_8_4__VNW
+ gf180mcu_fd_sc_mcu9t5v0__fill_8_4__VPW VSS gf180mcu_fd_sc_mcu9t5v0__fill_8
* cell instance gf180mcu_fd_sc_mcu9t5v0__fill_8_5 r0 *1 0,0
Xgf180mcu_fd_sc_mcu9t5v0__fill_8_5 VDD gf180mcu_fd_sc_mcu9t5v0__fill_8_5__VNW
+ gf180mcu_fd_sc_mcu9t5v0__fill_8_5__VPW VSS gf180mcu_fd_sc_mcu9t5v0__fill_8
* cell instance gf180mcu_fd_sc_mcu9t5v0__fill_8_6 r0 *1 0,0
Xgf180mcu_fd_sc_mcu9t5v0__fill_8_6 VDD gf180mcu_fd_sc_mcu9t5v0__fill_8_6__VNW
+ VDD VSS gf180mcu_fd_sc_mcu9t5v0__fill_8
* cell instance gf180mcu_fd_sc_mcu9t5v0__fill_8_7 r0 *1 0,0
Xgf180mcu_fd_sc_mcu9t5v0__fill_8_7 VDD gf180mcu_fd_sc_mcu9t5v0__fill_8_7__VNW
+ VDD VSS gf180mcu_fd_sc_mcu9t5v0__fill_8
* cell instance gf180mcu_fd_sc_mcu9t5v0__fill_8_8 r0 *1 0,0
Xgf180mcu_fd_sc_mcu9t5v0__fill_8_8 VDD gf180mcu_fd_sc_mcu9t5v0__fill_8_8__VNW
+ gf180mcu_fd_sc_mcu9t5v0__fill_8_8__VPW VSS gf180mcu_fd_sc_mcu9t5v0__fill_8
* cell instance gf180mcu_fd_sc_mcu9t5v0__fill_8_9 r0 *1 0,0
Xgf180mcu_fd_sc_mcu9t5v0__fill_8_9 VDD gf180mcu_fd_sc_mcu9t5v0__fill_8_9__VNW
+ gf180mcu_fd_sc_mcu9t5v0__fill_8_9__VPW VSS gf180mcu_fd_sc_mcu9t5v0__fill_8
* cell instance gf180mcu_fd_sc_mcu9t5v0__fill_8_10 r0 *1 0,0
Xgf180mcu_fd_sc_mcu9t5v0__fill_8_10 VDD VSS VSS VSS
+ gf180mcu_fd_sc_mcu9t5v0__fill_8
* cell instance gf180mcu_fd_sc_mcu9t5v0__fill_8_11 r0 *1 0,0
Xgf180mcu_fd_sc_mcu9t5v0__fill_8_11 VDD VSS VSS VSS
+ gf180mcu_fd_sc_mcu9t5v0__fill_8
* cell instance gf180mcu_fd_sc_mcu9t5v0__fill_8_12 r0 *1 0,0
Xgf180mcu_fd_sc_mcu9t5v0__fill_8_12 VDD VSS VSS VSS
+ gf180mcu_fd_sc_mcu9t5v0__fill_8
* cell instance gf180mcu_fd_sc_mcu9t5v0__fill_8_13 r0 *1 0,0
Xgf180mcu_fd_sc_mcu9t5v0__fill_8_13 VDD VSS VSS VSS
+ gf180mcu_fd_sc_mcu9t5v0__fill_8
* cell instance gf180mcu_fd_sc_mcu9t5v0__fill_8_14 r0 *1 0,0
Xgf180mcu_fd_sc_mcu9t5v0__fill_8_14 VDD VSS VSS VSS
+ gf180mcu_fd_sc_mcu9t5v0__fill_8
* cell instance gf180mcu_fd_sc_mcu9t5v0__fill_8_15 r0 *1 0,0
Xgf180mcu_fd_sc_mcu9t5v0__fill_8_15 VDD VSS VSS VSS
+ gf180mcu_fd_sc_mcu9t5v0__fill_8
* cell instance gf180mcu_fd_sc_mcu9t5v0__fill_8_16 r0 *1 0,0
Xgf180mcu_fd_sc_mcu9t5v0__fill_8_16 VDD VDD VDD VSS
+ gf180mcu_fd_sc_mcu9t5v0__fill_8
* cell instance gf180mcu_fd_sc_mcu9t5v0__fill_8_17 r0 *1 0,0
Xgf180mcu_fd_sc_mcu9t5v0__fill_8_17 VDD \_002_ VDD VSS
+ gf180mcu_fd_sc_mcu9t5v0__fill_8
* cell instance gf180mcu_fd_sc_mcu9t5v0__fill_8_18 r0 *1 0,0
Xgf180mcu_fd_sc_mcu9t5v0__fill_8_18 VDD VDD VDD VSS
+ gf180mcu_fd_sc_mcu9t5v0__fill_8
* cell instance gf180mcu_fd_sc_mcu9t5v0__fill_8_19 r0 *1 0,0
Xgf180mcu_fd_sc_mcu9t5v0__fill_8_19 VDD VDD VDD VSS
+ gf180mcu_fd_sc_mcu9t5v0__fill_8
* cell instance gf180mcu_fd_sc_mcu9t5v0__fill_8_20 r0 *1 0,0
Xgf180mcu_fd_sc_mcu9t5v0__fill_8_20 VDD VDD VDD VSS
+ gf180mcu_fd_sc_mcu9t5v0__fill_8
* cell instance gf180mcu_fd_sc_mcu9t5v0__fill_8_21 r0 *1 0,0
Xgf180mcu_fd_sc_mcu9t5v0__fill_8_21 VDD VDD VDD VSS
+ gf180mcu_fd_sc_mcu9t5v0__fill_8
* cell instance gf180mcu_fd_sc_mcu9t5v0__fill_8_22 r0 *1 0,0
Xgf180mcu_fd_sc_mcu9t5v0__fill_8_22 VDD gf180mcu_fd_sc_mcu9t5v0__fill_8_22__VNW
+ gf180mcu_fd_sc_mcu9t5v0__fill_8_22__VPW VSS gf180mcu_fd_sc_mcu9t5v0__fill_8
* cell instance gf180mcu_fd_sc_mcu9t5v0__fill_8_23 r0 *1 0,0
Xgf180mcu_fd_sc_mcu9t5v0__fill_8_23 VDD clknet_3_0__leaf_clk
+ clknet_3_0__leaf_clk VSS gf180mcu_fd_sc_mcu9t5v0__fill_8
* cell instance gf180mcu_fd_sc_mcu9t5v0__fill_8_24 r0 *1 0,0
Xgf180mcu_fd_sc_mcu9t5v0__fill_8_24 VDD gf180mcu_fd_sc_mcu9t5v0__fill_8_24__VNW
+ gf180mcu_fd_sc_mcu9t5v0__fill_8_24__VPW VSS gf180mcu_fd_sc_mcu9t5v0__fill_8
* cell instance gf180mcu_fd_sc_mcu9t5v0__fill_8_25 r0 *1 0,0
Xgf180mcu_fd_sc_mcu9t5v0__fill_8_25 VDD gf180mcu_fd_sc_mcu9t5v0__fill_8_25__VNW
+ VDD VSS gf180mcu_fd_sc_mcu9t5v0__fill_8
* cell instance gf180mcu_fd_sc_mcu9t5v0__fill_8_26 r0 *1 0,0
Xgf180mcu_fd_sc_mcu9t5v0__fill_8_26 VDD DataIn[2] DataIn[2] VSS
+ gf180mcu_fd_sc_mcu9t5v0__fill_8
* cell instance gf180mcu_fd_sc_mcu9t5v0__fill_8_27 r0 *1 0,0
Xgf180mcu_fd_sc_mcu9t5v0__fill_8_27 VDD gf180mcu_fd_sc_mcu9t5v0__fill_8_27__VNW
+ gf180mcu_fd_sc_mcu9t5v0__fill_8_27__VPW VSS gf180mcu_fd_sc_mcu9t5v0__fill_8
* cell instance gf180mcu_fd_sc_mcu9t5v0__fill_8_28 r0 *1 0,0
Xgf180mcu_fd_sc_mcu9t5v0__fill_8_28 VDD gf180mcu_fd_sc_mcu9t5v0__fill_8_28__VNW
+ VDD VSS gf180mcu_fd_sc_mcu9t5v0__fill_8
* cell instance gf180mcu_fd_sc_mcu9t5v0__fill_8_29 r0 *1 0,0
Xgf180mcu_fd_sc_mcu9t5v0__fill_8_29 VDD gf180mcu_fd_sc_mcu9t5v0__fill_8_29__VNW
+ gf180mcu_fd_sc_mcu9t5v0__fill_8_29__VPW VSS gf180mcu_fd_sc_mcu9t5v0__fill_8
* cell instance gf180mcu_fd_sc_mcu9t5v0__fill_8_30 r0 *1 0,0
Xgf180mcu_fd_sc_mcu9t5v0__fill_8_30 VDD \_056_
+ gf180mcu_fd_sc_mcu9t5v0__fill_8_30__VPW VSS gf180mcu_fd_sc_mcu9t5v0__fill_8
* cell instance gf180mcu_fd_sc_mcu9t5v0__fill_8_31 r0 *1 0,0
Xgf180mcu_fd_sc_mcu9t5v0__fill_8_31 VDD gf180mcu_fd_sc_mcu9t5v0__fill_8_31__VNW
+ gf180mcu_fd_sc_mcu9t5v0__fill_8_31__VPW VSS gf180mcu_fd_sc_mcu9t5v0__fill_8
* cell instance gf180mcu_fd_sc_mcu9t5v0__fill_8_32 r0 *1 0,0
Xgf180mcu_fd_sc_mcu9t5v0__fill_8_32 VDD gf180mcu_fd_sc_mcu9t5v0__fill_8_32__VNW
+ gf180mcu_fd_sc_mcu9t5v0__fill_8_32__VPW VSS gf180mcu_fd_sc_mcu9t5v0__fill_8
* cell instance gf180mcu_fd_sc_mcu9t5v0__fill_8_33 r0 *1 0,0
Xgf180mcu_fd_sc_mcu9t5v0__fill_8_33 VDD gf180mcu_fd_sc_mcu9t5v0__fill_8_33__VNW
+ gf180mcu_fd_sc_mcu9t5v0__fill_8_33__VPW VSS gf180mcu_fd_sc_mcu9t5v0__fill_8
* cell instance gf180mcu_fd_sc_mcu9t5v0__fill_8_34 r0 *1 0,0
Xgf180mcu_fd_sc_mcu9t5v0__fill_8_34 VDD rx_shift[1]
+ gf180mcu_fd_sc_mcu9t5v0__fill_8_34__VPW VSS gf180mcu_fd_sc_mcu9t5v0__fill_8
* cell instance gf180mcu_fd_sc_mcu9t5v0__fill_8_35 r0 *1 0,0
Xgf180mcu_fd_sc_mcu9t5v0__fill_8_35 VDD gf180mcu_fd_sc_mcu9t5v0__fill_8_35__VNW
+ gf180mcu_fd_sc_mcu9t5v0__fill_8_35__VPW VSS gf180mcu_fd_sc_mcu9t5v0__fill_8
* cell instance gf180mcu_fd_sc_mcu9t5v0__fill_8_36 r0 *1 0,0
Xgf180mcu_fd_sc_mcu9t5v0__fill_8_36 VDD gf180mcu_fd_sc_mcu9t5v0__fill_8_36__VNW
+ gf180mcu_fd_sc_mcu9t5v0__fill_8_36__VPW VSS gf180mcu_fd_sc_mcu9t5v0__fill_8
* cell instance gf180mcu_fd_sc_mcu9t5v0__fill_8_37 r0 *1 0,0
Xgf180mcu_fd_sc_mcu9t5v0__fill_8_37 VDD gf180mcu_fd_sc_mcu9t5v0__fill_8_37__VNW
+ gf180mcu_fd_sc_mcu9t5v0__fill_8_37__VPW VSS gf180mcu_fd_sc_mcu9t5v0__fill_8
* cell instance gf180mcu_fd_sc_mcu9t5v0__fill_8_38 r0 *1 0,0
Xgf180mcu_fd_sc_mcu9t5v0__fill_8_38 VDD gf180mcu_fd_sc_mcu9t5v0__fill_8_38__VNW
+ gf180mcu_fd_sc_mcu9t5v0__fill_8_38__VPW VSS gf180mcu_fd_sc_mcu9t5v0__fill_8
* cell instance gf180mcu_fd_sc_mcu9t5v0__fill_8_39 r0 *1 0,0
Xgf180mcu_fd_sc_mcu9t5v0__fill_8_39 VDD VSS VSS VSS
+ gf180mcu_fd_sc_mcu9t5v0__fill_8
* cell instance gf180mcu_fd_sc_mcu9t5v0__fill_8_40 r0 *1 0,0
Xgf180mcu_fd_sc_mcu9t5v0__fill_8_40 VDD VSS VSS VSS
+ gf180mcu_fd_sc_mcu9t5v0__fill_8
* cell instance gf180mcu_fd_sc_mcu9t5v0__fill_8_41 r0 *1 0,0
Xgf180mcu_fd_sc_mcu9t5v0__fill_8_41 VDD VSS VSS VSS
+ gf180mcu_fd_sc_mcu9t5v0__fill_8
* cell instance gf180mcu_fd_sc_mcu9t5v0__fill_8_42 r0 *1 0,0
Xgf180mcu_fd_sc_mcu9t5v0__fill_8_42 VDD VDD VDD VSS
+ gf180mcu_fd_sc_mcu9t5v0__fill_8
* cell instance gf180mcu_fd_sc_mcu9t5v0__fill_8_43 r0 *1 0,0
Xgf180mcu_fd_sc_mcu9t5v0__fill_8_43 VDD VDD VDD VSS
+ gf180mcu_fd_sc_mcu9t5v0__fill_8
* cell instance gf180mcu_fd_sc_mcu9t5v0__fill_8_44 r0 *1 0,0
Xgf180mcu_fd_sc_mcu9t5v0__fill_8_44 VDD VDD VDD VSS
+ gf180mcu_fd_sc_mcu9t5v0__fill_8
* cell instance gf180mcu_fd_sc_mcu9t5v0__fill_8_45 r0 *1 0,0
Xgf180mcu_fd_sc_mcu9t5v0__fill_8_45 VDD VDD VDD VSS
+ gf180mcu_fd_sc_mcu9t5v0__fill_8
* cell instance gf180mcu_fd_sc_mcu9t5v0__fill_8_46 r0 *1 0,0
Xgf180mcu_fd_sc_mcu9t5v0__fill_8_46 VDD VDD VDD VSS
+ gf180mcu_fd_sc_mcu9t5v0__fill_8
* cell instance gf180mcu_fd_sc_mcu9t5v0__fill_8_47 r0 *1 0,0
Xgf180mcu_fd_sc_mcu9t5v0__fill_8_47 VDD VDD VDD VSS
+ gf180mcu_fd_sc_mcu9t5v0__fill_8
* cell instance gf180mcu_fd_sc_mcu9t5v0__fill_8_48 r0 *1 0,0
Xgf180mcu_fd_sc_mcu9t5v0__fill_8_48 VDD gf180mcu_fd_sc_mcu9t5v0__fill_8_48__VNW
+ gf180mcu_fd_sc_mcu9t5v0__fill_8_48__VPW VSS gf180mcu_fd_sc_mcu9t5v0__fill_8
* cell instance gf180mcu_fd_sc_mcu9t5v0__fill_8_49 r0 *1 0,0
Xgf180mcu_fd_sc_mcu9t5v0__fill_8_49 VDD gf180mcu_fd_sc_mcu9t5v0__fill_8_49__VNW
+ gf180mcu_fd_sc_mcu9t5v0__fill_8_49__VPW VSS gf180mcu_fd_sc_mcu9t5v0__fill_8
* cell instance gf180mcu_fd_sc_mcu9t5v0__fill_8_50 r0 *1 0,0
Xgf180mcu_fd_sc_mcu9t5v0__fill_8_50 VDD gf180mcu_fd_sc_mcu9t5v0__fill_8_50__VNW
+ gf180mcu_fd_sc_mcu9t5v0__fill_8_50__VPW VSS gf180mcu_fd_sc_mcu9t5v0__fill_8
* cell instance gf180mcu_fd_sc_mcu9t5v0__fill_8_51 r0 *1 0,0
Xgf180mcu_fd_sc_mcu9t5v0__fill_8_51 VDD DataIn[7] DataIn[7] VSS
+ gf180mcu_fd_sc_mcu9t5v0__fill_8
* cell instance gf180mcu_fd_sc_mcu9t5v0__fill_8_52 r0 *1 0,0
Xgf180mcu_fd_sc_mcu9t5v0__fill_8_52 VDD gf180mcu_fd_sc_mcu9t5v0__fill_8_52__VNW
+ gf180mcu_fd_sc_mcu9t5v0__fill_8_52__VPW VSS gf180mcu_fd_sc_mcu9t5v0__fill_8
* cell instance gf180mcu_fd_sc_mcu9t5v0__fill_8_53 r0 *1 0,0
Xgf180mcu_fd_sc_mcu9t5v0__fill_8_53 VDD gf180mcu_fd_sc_mcu9t5v0__fill_8_53__VNW
+ DataIn[6] VSS gf180mcu_fd_sc_mcu9t5v0__fill_8
* cell instance gf180mcu_fd_sc_mcu9t5v0__fill_8_54 r0 *1 0,0
Xgf180mcu_fd_sc_mcu9t5v0__fill_8_54 VDD gf180mcu_fd_sc_mcu9t5v0__fill_8_54__VNW
+ gf180mcu_fd_sc_mcu9t5v0__fill_8_54__VPW VSS gf180mcu_fd_sc_mcu9t5v0__fill_8
* cell instance gf180mcu_fd_sc_mcu9t5v0__fill_8_55 r0 *1 0,0
Xgf180mcu_fd_sc_mcu9t5v0__fill_8_55 VDD gf180mcu_fd_sc_mcu9t5v0__fill_8_55__VNW
+ gf180mcu_fd_sc_mcu9t5v0__fill_8_55__VPW VSS gf180mcu_fd_sc_mcu9t5v0__fill_8
* cell instance gf180mcu_fd_sc_mcu9t5v0__fill_8_56 r0 *1 0,0
Xgf180mcu_fd_sc_mcu9t5v0__fill_8_56 VDD gf180mcu_fd_sc_mcu9t5v0__fill_8_56__VNW
+ gf180mcu_fd_sc_mcu9t5v0__fill_8_56__VPW VSS gf180mcu_fd_sc_mcu9t5v0__fill_8
* cell instance gf180mcu_fd_sc_mcu9t5v0__fill_8_57 r0 *1 0,0
Xgf180mcu_fd_sc_mcu9t5v0__fill_8_57 VDD u_eop_detector/se0_count[2]
+ gf180mcu_fd_sc_mcu9t5v0__fill_8_57__VPW VSS gf180mcu_fd_sc_mcu9t5v0__fill_8
* cell instance gf180mcu_fd_sc_mcu9t5v0__fill_8_58 r0 *1 0,0
Xgf180mcu_fd_sc_mcu9t5v0__fill_8_58 VDD gf180mcu_fd_sc_mcu9t5v0__fill_8_58__VNW
+ gf180mcu_fd_sc_mcu9t5v0__fill_8_58__VPW VSS gf180mcu_fd_sc_mcu9t5v0__fill_8
* cell instance gf180mcu_fd_sc_mcu9t5v0__fill_8_59 r0 *1 0,0
Xgf180mcu_fd_sc_mcu9t5v0__fill_8_59 VDD gf180mcu_fd_sc_mcu9t5v0__fill_8_59__VNW
+ gf180mcu_fd_sc_mcu9t5v0__fill_8_59__VPW VSS gf180mcu_fd_sc_mcu9t5v0__fill_8
* cell instance gf180mcu_fd_sc_mcu9t5v0__fill_8_60 r0 *1 0,0
Xgf180mcu_fd_sc_mcu9t5v0__fill_8_60 VDD VSS
+ gf180mcu_fd_sc_mcu9t5v0__fill_8_60__VPW VSS gf180mcu_fd_sc_mcu9t5v0__fill_8
* cell instance gf180mcu_fd_sc_mcu9t5v0__fill_8_61 r0 *1 0,0
Xgf180mcu_fd_sc_mcu9t5v0__fill_8_61 VDD gf180mcu_fd_sc_mcu9t5v0__fill_8_61__VNW
+ rst_n VSS gf180mcu_fd_sc_mcu9t5v0__fill_8
* cell instance gf180mcu_fd_sc_mcu9t5v0__fill_8_62 r0 *1 0,0
Xgf180mcu_fd_sc_mcu9t5v0__fill_8_62 VDD VSS
+ gf180mcu_fd_sc_mcu9t5v0__fill_8_62__VPW VSS gf180mcu_fd_sc_mcu9t5v0__fill_8
* cell instance gf180mcu_fd_sc_mcu9t5v0__fill_8_63 r0 *1 0,0
Xgf180mcu_fd_sc_mcu9t5v0__fill_8_63 VDD u_eop_detector/_09_
+ gf180mcu_fd_sc_mcu9t5v0__fill_8_63__VPW VSS gf180mcu_fd_sc_mcu9t5v0__fill_8
* cell instance gf180mcu_fd_sc_mcu9t5v0__fill_8_64 r0 *1 0,0
Xgf180mcu_fd_sc_mcu9t5v0__fill_8_64 VDD gf180mcu_fd_sc_mcu9t5v0__fill_8_64__VNW
+ gf180mcu_fd_sc_mcu9t5v0__fill_8_64__VPW VSS gf180mcu_fd_sc_mcu9t5v0__fill_8
* cell instance gf180mcu_fd_sc_mcu9t5v0__fill_8_65 r0 *1 0,0
Xgf180mcu_fd_sc_mcu9t5v0__fill_8_65 VDD DataIn[0]
+ gf180mcu_fd_sc_mcu9t5v0__fill_8_65__VPW VSS gf180mcu_fd_sc_mcu9t5v0__fill_8
* cell instance gf180mcu_fd_sc_mcu9t5v0__fill_8_66 r0 *1 0,0
Xgf180mcu_fd_sc_mcu9t5v0__fill_8_66 VDD gf180mcu_fd_sc_mcu9t5v0__fill_8_66__VNW
+ gf180mcu_fd_sc_mcu9t5v0__fill_8_66__VPW VSS gf180mcu_fd_sc_mcu9t5v0__fill_8
* cell instance gf180mcu_fd_sc_mcu9t5v0__fill_8_67 r0 *1 0,0
Xgf180mcu_fd_sc_mcu9t5v0__fill_8_67 VDD gf180mcu_fd_sc_mcu9t5v0__fill_8_67__VNW
+ gf180mcu_fd_sc_mcu9t5v0__fill_8_67__VPW VSS gf180mcu_fd_sc_mcu9t5v0__fill_8
* cell instance gf180mcu_fd_sc_mcu9t5v0__fill_8_68 r0 *1 0,0
Xgf180mcu_fd_sc_mcu9t5v0__fill_8_68 VDD gf180mcu_fd_sc_mcu9t5v0__fill_8_68__VNW
+ gf180mcu_fd_sc_mcu9t5v0__fill_8_68__VPW VSS gf180mcu_fd_sc_mcu9t5v0__fill_8
* cell instance gf180mcu_fd_sc_mcu9t5v0__fill_8_69 r0 *1 0,0
Xgf180mcu_fd_sc_mcu9t5v0__fill_8_69 VDD gf180mcu_fd_sc_mcu9t5v0__fill_8_69__VNW
+ gf180mcu_fd_sc_mcu9t5v0__fill_8_69__VPW VSS gf180mcu_fd_sc_mcu9t5v0__fill_8
* cell instance gf180mcu_fd_sc_mcu9t5v0__fill_8_70 r0 *1 0,0
Xgf180mcu_fd_sc_mcu9t5v0__fill_8_70 VDD gf180mcu_fd_sc_mcu9t5v0__fill_8_70__VNW
+ gf180mcu_fd_sc_mcu9t5v0__fill_8_70__VPW VSS gf180mcu_fd_sc_mcu9t5v0__fill_8
* cell instance gf180mcu_fd_sc_mcu9t5v0__fill_8_71 r0 *1 0,0
Xgf180mcu_fd_sc_mcu9t5v0__fill_8_71 VDD gf180mcu_fd_sc_mcu9t5v0__fill_8_71__VNW
+ gf180mcu_fd_sc_mcu9t5v0__fill_8_71__VPW VSS gf180mcu_fd_sc_mcu9t5v0__fill_8
* cell instance gf180mcu_fd_sc_mcu9t5v0__fill_8_72 r0 *1 0,0
Xgf180mcu_fd_sc_mcu9t5v0__fill_8_72 VDD gf180mcu_fd_sc_mcu9t5v0__fill_8_72__VNW
+ gf180mcu_fd_sc_mcu9t5v0__fill_8_72__VPW VSS gf180mcu_fd_sc_mcu9t5v0__fill_8
* cell instance gf180mcu_fd_sc_mcu9t5v0__fill_8_73 r0 *1 0,0
Xgf180mcu_fd_sc_mcu9t5v0__fill_8_73 VDD VSS
+ gf180mcu_fd_sc_mcu9t5v0__fill_8_73__VPW VSS gf180mcu_fd_sc_mcu9t5v0__fill_8
* cell instance gf180mcu_fd_sc_mcu9t5v0__fill_8_74 r0 *1 0,0
Xgf180mcu_fd_sc_mcu9t5v0__fill_8_74 VDD gf180mcu_fd_sc_mcu9t5v0__fill_8_74__VNW
+ gf180mcu_fd_sc_mcu9t5v0__fill_8_74__VPW VSS gf180mcu_fd_sc_mcu9t5v0__fill_8
* cell instance gf180mcu_fd_sc_mcu9t5v0__fill_8_75 r0 *1 0,0
Xgf180mcu_fd_sc_mcu9t5v0__fill_8_75 VDD gf180mcu_fd_sc_mcu9t5v0__fill_8_75__VNW
+ gf180mcu_fd_sc_mcu9t5v0__fill_8_75__VPW VSS gf180mcu_fd_sc_mcu9t5v0__fill_8
* cell instance gf180mcu_fd_sc_mcu9t5v0__fill_8_76 r0 *1 0,0
Xgf180mcu_fd_sc_mcu9t5v0__fill_8_76 VDD gf180mcu_fd_sc_mcu9t5v0__fill_8_76__VNW
+ gf180mcu_fd_sc_mcu9t5v0__fill_8_76__VPW VSS gf180mcu_fd_sc_mcu9t5v0__fill_8
* cell instance gf180mcu_fd_sc_mcu9t5v0__fill_8_77 r0 *1 0,0
Xgf180mcu_fd_sc_mcu9t5v0__fill_8_77 VDD TxValid TxValid VSS
+ gf180mcu_fd_sc_mcu9t5v0__fill_8
* cell instance gf180mcu_fd_sc_mcu9t5v0__fill_8_78 r0 *1 0,0
Xgf180mcu_fd_sc_mcu9t5v0__fill_8_78 VDD gf180mcu_fd_sc_mcu9t5v0__fill_8_78__VNW
+ gf180mcu_fd_sc_mcu9t5v0__fill_8_78__VPW VSS gf180mcu_fd_sc_mcu9t5v0__fill_8
* cell instance gf180mcu_fd_sc_mcu9t5v0__fill_8_79 r0 *1 0,0
Xgf180mcu_fd_sc_mcu9t5v0__fill_8_79 VDD \_077_
+ gf180mcu_fd_sc_mcu9t5v0__fill_8_79__VPW VSS gf180mcu_fd_sc_mcu9t5v0__fill_8
* cell instance gf180mcu_fd_sc_mcu9t5v0__fill_8_80 r0 *1 0,0
Xgf180mcu_fd_sc_mcu9t5v0__fill_8_80 VDD gf180mcu_fd_sc_mcu9t5v0__fill_8_80__VNW
+ gf180mcu_fd_sc_mcu9t5v0__fill_8_80__VPW VSS gf180mcu_fd_sc_mcu9t5v0__fill_8
* cell instance gf180mcu_fd_sc_mcu9t5v0__fill_8_81 r0 *1 0,0
Xgf180mcu_fd_sc_mcu9t5v0__fill_8_81 VDD VSS VSS VSS
+ gf180mcu_fd_sc_mcu9t5v0__fill_8
* cell instance gf180mcu_fd_sc_mcu9t5v0__fill_8_82 r0 *1 0,0
Xgf180mcu_fd_sc_mcu9t5v0__fill_8_82 VDD VDD VDD VSS
+ gf180mcu_fd_sc_mcu9t5v0__fill_8
* cell instance gf180mcu_fd_sc_mcu9t5v0__fill_8_83 r0 *1 0,0
Xgf180mcu_fd_sc_mcu9t5v0__fill_8_83 VDD VDD VDD VSS
+ gf180mcu_fd_sc_mcu9t5v0__fill_8
* cell instance gf180mcu_fd_sc_mcu9t5v0__fill_8_84 r0 *1 0,0
Xgf180mcu_fd_sc_mcu9t5v0__fill_8_84 VDD \_162_ VDD VSS
+ gf180mcu_fd_sc_mcu9t5v0__fill_8
* cell instance gf180mcu_fd_sc_mcu9t5v0__fill_8_85 r0 *1 0,0
Xgf180mcu_fd_sc_mcu9t5v0__fill_8_85 VDD \_077_ VDD VSS
+ gf180mcu_fd_sc_mcu9t5v0__fill_8
* cell instance gf180mcu_fd_sc_mcu9t5v0__fill_8_86 r0 *1 0,0
Xgf180mcu_fd_sc_mcu9t5v0__fill_8_86 VDD gf180mcu_fd_sc_mcu9t5v0__fill_8_86__VNW
+ gf180mcu_fd_sc_mcu9t5v0__fill_8_86__VPW VSS gf180mcu_fd_sc_mcu9t5v0__fill_8
* cell instance gf180mcu_fd_sc_mcu9t5v0__fill_8_87 r0 *1 0,0
Xgf180mcu_fd_sc_mcu9t5v0__fill_8_87 VDD VDD VDD VSS
+ gf180mcu_fd_sc_mcu9t5v0__fill_8
* cell instance gf180mcu_fd_sc_mcu9t5v0__fill_8_88 r0 *1 0,0
Xgf180mcu_fd_sc_mcu9t5v0__fill_8_88 VDD gf180mcu_fd_sc_mcu9t5v0__fill_8_88__VNW
+ gf180mcu_fd_sc_mcu9t5v0__fill_8_88__VPW VSS gf180mcu_fd_sc_mcu9t5v0__fill_8
* cell instance gf180mcu_fd_sc_mcu9t5v0__fill_8_89 r0 *1 0,0
Xgf180mcu_fd_sc_mcu9t5v0__fill_8_89 VDD gf180mcu_fd_sc_mcu9t5v0__fill_8_89__VNW
+ gf180mcu_fd_sc_mcu9t5v0__fill_8_89__VPW VSS gf180mcu_fd_sc_mcu9t5v0__fill_8
* cell instance gf180mcu_fd_sc_mcu9t5v0__fill_8_90 r0 *1 0,0
Xgf180mcu_fd_sc_mcu9t5v0__fill_8_90 VDD gf180mcu_fd_sc_mcu9t5v0__fill_8_90__VNW
+ gf180mcu_fd_sc_mcu9t5v0__fill_8_90__VPW VSS gf180mcu_fd_sc_mcu9t5v0__fill_8
* cell instance gf180mcu_fd_sc_mcu9t5v0__fill_8_91 r0 *1 0,0
Xgf180mcu_fd_sc_mcu9t5v0__fill_8_91 VDD \_072_
+ gf180mcu_fd_sc_mcu9t5v0__fill_8_91__VPW VSS gf180mcu_fd_sc_mcu9t5v0__fill_8
* cell instance gf180mcu_fd_sc_mcu9t5v0__fill_8_92 r0 *1 0,0
Xgf180mcu_fd_sc_mcu9t5v0__fill_8_92 VDD gf180mcu_fd_sc_mcu9t5v0__fill_8_92__VNW
+ VDD VSS gf180mcu_fd_sc_mcu9t5v0__fill_8
* cell instance gf180mcu_fd_sc_mcu9t5v0__fill_8_93 r0 *1 0,0
Xgf180mcu_fd_sc_mcu9t5v0__fill_8_93 VDD VSS
+ gf180mcu_fd_sc_mcu9t5v0__fill_8_93__VPW VSS gf180mcu_fd_sc_mcu9t5v0__fill_8
* cell instance gf180mcu_fd_sc_mcu9t5v0__fill_8_94 r0 *1 0,0
Xgf180mcu_fd_sc_mcu9t5v0__fill_8_94 VDD gf180mcu_fd_sc_mcu9t5v0__fill_8_94__VNW
+ gf180mcu_fd_sc_mcu9t5v0__fill_8_94__VPW VSS gf180mcu_fd_sc_mcu9t5v0__fill_8
* cell instance gf180mcu_fd_sc_mcu9t5v0__fill_8_95 r0 *1 0,0
Xgf180mcu_fd_sc_mcu9t5v0__fill_8_95 VDD gf180mcu_fd_sc_mcu9t5v0__fill_8_95__VNW
+ gf180mcu_fd_sc_mcu9t5v0__fill_8_95__VPW VSS gf180mcu_fd_sc_mcu9t5v0__fill_8
* cell instance gf180mcu_fd_sc_mcu9t5v0__fill_8_96 r0 *1 0,0
Xgf180mcu_fd_sc_mcu9t5v0__fill_8_96 VDD \_064_
+ gf180mcu_fd_sc_mcu9t5v0__fill_8_96__VPW VSS gf180mcu_fd_sc_mcu9t5v0__fill_8
* cell instance gf180mcu_fd_sc_mcu9t5v0__fill_8_97 r0 *1 0,0
Xgf180mcu_fd_sc_mcu9t5v0__fill_8_97 VDD \_093_ \_093_ VSS
+ gf180mcu_fd_sc_mcu9t5v0__fill_8
* cell instance gf180mcu_fd_sc_mcu9t5v0__fill_8_98 r0 *1 0,0
Xgf180mcu_fd_sc_mcu9t5v0__fill_8_98 VDD gf180mcu_fd_sc_mcu9t5v0__fill_8_98__VNW
+ \_109_ VSS gf180mcu_fd_sc_mcu9t5v0__fill_8
* cell instance gf180mcu_fd_sc_mcu9t5v0__fill_8_99 r0 *1 0,0
Xgf180mcu_fd_sc_mcu9t5v0__fill_8_99 VDD VSS VSS VSS
+ gf180mcu_fd_sc_mcu9t5v0__fill_8
* cell instance gf180mcu_fd_sc_mcu9t5v0__fill_8_100 r0 *1 0,0
Xgf180mcu_fd_sc_mcu9t5v0__fill_8_100 VDD VSS VSS VSS
+ gf180mcu_fd_sc_mcu9t5v0__fill_8
* cell instance gf180mcu_fd_sc_mcu9t5v0__fill_8_101 r0 *1 0,0
Xgf180mcu_fd_sc_mcu9t5v0__fill_8_101 VDD VSS VSS VSS
+ gf180mcu_fd_sc_mcu9t5v0__fill_8
* cell instance gf180mcu_fd_sc_mcu9t5v0__fill_8_102 r0 *1 0,0
Xgf180mcu_fd_sc_mcu9t5v0__fill_8_102 VDD VSS VSS VSS
+ gf180mcu_fd_sc_mcu9t5v0__fill_8
* cell instance gf180mcu_fd_sc_mcu9t5v0__fill_8_103 r0 *1 0,0
Xgf180mcu_fd_sc_mcu9t5v0__fill_8_103 VDD VSS VSS VSS
+ gf180mcu_fd_sc_mcu9t5v0__fill_8
* cell instance gf180mcu_fd_sc_mcu9t5v0__fill_8_104 r0 *1 0,0
Xgf180mcu_fd_sc_mcu9t5v0__fill_8_104 VDD VDD VDD VSS
+ gf180mcu_fd_sc_mcu9t5v0__fill_8
* cell instance gf180mcu_fd_sc_mcu9t5v0__fill_8_105 r0 *1 0,0
Xgf180mcu_fd_sc_mcu9t5v0__fill_8_105 VDD
+ gf180mcu_fd_sc_mcu9t5v0__fill_8_105__VNW
+ gf180mcu_fd_sc_mcu9t5v0__fill_8_105__VPW VSS gf180mcu_fd_sc_mcu9t5v0__fill_8
* cell instance gf180mcu_fd_sc_mcu9t5v0__fill_8_106 r0 *1 0,0
Xgf180mcu_fd_sc_mcu9t5v0__fill_8_106 VDD
+ gf180mcu_fd_sc_mcu9t5v0__fill_8_106__VNW
+ gf180mcu_fd_sc_mcu9t5v0__fill_8_106__VPW VSS gf180mcu_fd_sc_mcu9t5v0__fill_8
* cell instance gf180mcu_fd_sc_mcu9t5v0__fill_8_107 r0 *1 0,0
Xgf180mcu_fd_sc_mcu9t5v0__fill_8_107 VDD
+ gf180mcu_fd_sc_mcu9t5v0__fill_8_107__VNW
+ gf180mcu_fd_sc_mcu9t5v0__fill_8_107__VPW VSS gf180mcu_fd_sc_mcu9t5v0__fill_8
* cell instance gf180mcu_fd_sc_mcu9t5v0__fill_8_108 r0 *1 0,0
Xgf180mcu_fd_sc_mcu9t5v0__fill_8_108 VDD VSS
+ gf180mcu_fd_sc_mcu9t5v0__fill_8_108__VPW VSS gf180mcu_fd_sc_mcu9t5v0__fill_8
* cell instance gf180mcu_fd_sc_mcu9t5v0__fill_8_109 r0 *1 0,0
Xgf180mcu_fd_sc_mcu9t5v0__fill_8_109 VDD
+ gf180mcu_fd_sc_mcu9t5v0__fill_8_109__VNW
+ gf180mcu_fd_sc_mcu9t5v0__fill_8_109__VPW VSS gf180mcu_fd_sc_mcu9t5v0__fill_8
* cell instance gf180mcu_fd_sc_mcu9t5v0__fill_8_110 r0 *1 0,0
Xgf180mcu_fd_sc_mcu9t5v0__fill_8_110 VDD
+ gf180mcu_fd_sc_mcu9t5v0__fill_8_110__VNW
+ gf180mcu_fd_sc_mcu9t5v0__fill_8_110__VPW VSS gf180mcu_fd_sc_mcu9t5v0__fill_8
* cell instance gf180mcu_fd_sc_mcu9t5v0__fill_8_111 r0 *1 0,0
Xgf180mcu_fd_sc_mcu9t5v0__fill_8_111 VDD
+ gf180mcu_fd_sc_mcu9t5v0__fill_8_111__VNW
+ gf180mcu_fd_sc_mcu9t5v0__fill_8_111__VPW VSS gf180mcu_fd_sc_mcu9t5v0__fill_8
* cell instance gf180mcu_fd_sc_mcu9t5v0__fill_8_112 r0 *1 0,0
Xgf180mcu_fd_sc_mcu9t5v0__fill_8_112 VDD
+ gf180mcu_fd_sc_mcu9t5v0__fill_8_112__VNW
+ gf180mcu_fd_sc_mcu9t5v0__fill_8_112__VPW VSS gf180mcu_fd_sc_mcu9t5v0__fill_8
* cell instance gf180mcu_fd_sc_mcu9t5v0__fill_8_113 r0 *1 0,0
Xgf180mcu_fd_sc_mcu9t5v0__fill_8_113 VDD
+ gf180mcu_fd_sc_mcu9t5v0__fill_8_113__VNW
+ gf180mcu_fd_sc_mcu9t5v0__fill_8_113__VPW VSS gf180mcu_fd_sc_mcu9t5v0__fill_8
* cell instance gf180mcu_fd_sc_mcu9t5v0__fill_8_114 r0 *1 0,0
Xgf180mcu_fd_sc_mcu9t5v0__fill_8_114 VDD
+ gf180mcu_fd_sc_mcu9t5v0__fill_8_114__VNW
+ gf180mcu_fd_sc_mcu9t5v0__fill_8_114__VPW VSS gf180mcu_fd_sc_mcu9t5v0__fill_8
* cell instance gf180mcu_fd_sc_mcu9t5v0__fill_8_115 r0 *1 0,0
Xgf180mcu_fd_sc_mcu9t5v0__fill_8_115 VDD
+ gf180mcu_fd_sc_mcu9t5v0__fill_8_115__VNW
+ gf180mcu_fd_sc_mcu9t5v0__fill_8_115__VPW VSS gf180mcu_fd_sc_mcu9t5v0__fill_8
* cell instance gf180mcu_fd_sc_mcu9t5v0__fill_8_116 r0 *1 0,0
Xgf180mcu_fd_sc_mcu9t5v0__fill_8_116 VDD
+ gf180mcu_fd_sc_mcu9t5v0__fill_8_116__VNW
+ gf180mcu_fd_sc_mcu9t5v0__fill_8_116__VPW VSS gf180mcu_fd_sc_mcu9t5v0__fill_8
* cell instance gf180mcu_fd_sc_mcu9t5v0__fill_8_117 r0 *1 0,0
Xgf180mcu_fd_sc_mcu9t5v0__fill_8_117 VDD
+ gf180mcu_fd_sc_mcu9t5v0__fill_8_117__VNW
+ gf180mcu_fd_sc_mcu9t5v0__fill_8_117__VPW VSS gf180mcu_fd_sc_mcu9t5v0__fill_8
* cell instance gf180mcu_fd_sc_mcu9t5v0__fill_8_118 r0 *1 0,0
Xgf180mcu_fd_sc_mcu9t5v0__fill_8_118 VDD
+ gf180mcu_fd_sc_mcu9t5v0__fill_8_118__VNW
+ gf180mcu_fd_sc_mcu9t5v0__fill_8_118__VPW VSS gf180mcu_fd_sc_mcu9t5v0__fill_8
* cell instance gf180mcu_fd_sc_mcu9t5v0__filltie_0 r0 *1 0,0
Xgf180mcu_fd_sc_mcu9t5v0__filltie_0 VDD VSS gf180mcu_fd_sc_mcu9t5v0__filltie
* cell instance gf180mcu_fd_sc_mcu9t5v0__filltie_1 r0 *1 0,0
Xgf180mcu_fd_sc_mcu9t5v0__filltie_1 VDD VSS gf180mcu_fd_sc_mcu9t5v0__filltie
* cell instance gf180mcu_fd_sc_mcu9t5v0__filltie_2 r0 *1 0,0
Xgf180mcu_fd_sc_mcu9t5v0__filltie_2 VDD VSS gf180mcu_fd_sc_mcu9t5v0__filltie
* cell instance gf180mcu_fd_sc_mcu9t5v0__filltie_3 r0 *1 0,0
Xgf180mcu_fd_sc_mcu9t5v0__filltie_3 VDD VSS gf180mcu_fd_sc_mcu9t5v0__filltie
* cell instance gf180mcu_fd_sc_mcu9t5v0__filltie_4 r0 *1 0,0
Xgf180mcu_fd_sc_mcu9t5v0__filltie_4 VDD VSS gf180mcu_fd_sc_mcu9t5v0__filltie
* cell instance gf180mcu_fd_sc_mcu9t5v0__filltie_5 r0 *1 0,0
Xgf180mcu_fd_sc_mcu9t5v0__filltie_5 VDD VSS gf180mcu_fd_sc_mcu9t5v0__filltie
* cell instance gf180mcu_fd_sc_mcu9t5v0__filltie_6 r0 *1 0,0
Xgf180mcu_fd_sc_mcu9t5v0__filltie_6 VDD VSS gf180mcu_fd_sc_mcu9t5v0__filltie
* cell instance gf180mcu_fd_sc_mcu9t5v0__filltie_7 r0 *1 0,0
Xgf180mcu_fd_sc_mcu9t5v0__filltie_7 VDD VSS gf180mcu_fd_sc_mcu9t5v0__filltie
* cell instance gf180mcu_fd_sc_mcu9t5v0__filltie_8 r0 *1 0,0
Xgf180mcu_fd_sc_mcu9t5v0__filltie_8 VDD VSS gf180mcu_fd_sc_mcu9t5v0__filltie
* cell instance gf180mcu_fd_sc_mcu9t5v0__filltie_9 r0 *1 0,0
Xgf180mcu_fd_sc_mcu9t5v0__filltie_9 VDD VSS gf180mcu_fd_sc_mcu9t5v0__filltie
* cell instance gf180mcu_fd_sc_mcu9t5v0__filltie_10 r0 *1 0,0
Xgf180mcu_fd_sc_mcu9t5v0__filltie_10 VDD VSS gf180mcu_fd_sc_mcu9t5v0__filltie
* cell instance gf180mcu_fd_sc_mcu9t5v0__filltie_11 r0 *1 0,0
Xgf180mcu_fd_sc_mcu9t5v0__filltie_11 VDD VSS gf180mcu_fd_sc_mcu9t5v0__filltie
* cell instance gf180mcu_fd_sc_mcu9t5v0__filltie_12 r0 *1 0,0
Xgf180mcu_fd_sc_mcu9t5v0__filltie_12 VDD VSS gf180mcu_fd_sc_mcu9t5v0__filltie
* cell instance gf180mcu_fd_sc_mcu9t5v0__filltie_13 r0 *1 0,0
Xgf180mcu_fd_sc_mcu9t5v0__filltie_13 VDD VSS gf180mcu_fd_sc_mcu9t5v0__filltie
* cell instance gf180mcu_fd_sc_mcu9t5v0__filltie_14 r0 *1 0,0
Xgf180mcu_fd_sc_mcu9t5v0__filltie_14 VDD VSS gf180mcu_fd_sc_mcu9t5v0__filltie
* cell instance gf180mcu_fd_sc_mcu9t5v0__filltie_15 r0 *1 0,0
Xgf180mcu_fd_sc_mcu9t5v0__filltie_15 VDD VSS gf180mcu_fd_sc_mcu9t5v0__filltie
* cell instance gf180mcu_fd_sc_mcu9t5v0__filltie_16 r0 *1 0,0
Xgf180mcu_fd_sc_mcu9t5v0__filltie_16 VDD VSS gf180mcu_fd_sc_mcu9t5v0__filltie
* cell instance gf180mcu_fd_sc_mcu9t5v0__filltie_17 r0 *1 0,0
Xgf180mcu_fd_sc_mcu9t5v0__filltie_17 VDD VSS gf180mcu_fd_sc_mcu9t5v0__filltie
* cell instance gf180mcu_fd_sc_mcu9t5v0__inv_1_0 r0 *1 0,0
Xgf180mcu_fd_sc_mcu9t5v0__inv_1_0 u_eop_detector/se0_count[1] VDD VSS vsubs VSS
+ u_eop_detector/_14_ gf180mcu_fd_sc_mcu9t5v0__inv_1
* cell instance gf180mcu_fd_sc_mcu9t5v0__inv_2_0 r0 *1 0,0
Xgf180mcu_fd_sc_mcu9t5v0__inv_2_0 \_003_ VDD
+ gf180mcu_fd_sc_mcu9t5v0__inv_2_0__VNW vsubs VSS u_destuffer/_08_
+ gf180mcu_fd_sc_mcu9t5v0__inv_2
* cell instance gf180mcu_fd_sc_mcu9t5v0__inv_2_1 r0 *1 0,0
Xgf180mcu_fd_sc_mcu9t5v0__inv_2_1 u_destuffer/ones_run[0] VDD
+ gf180mcu_fd_sc_mcu9t5v0__inv_2_1__VNW vsubs VSS u_destuffer/_11_
+ gf180mcu_fd_sc_mcu9t5v0__inv_2
* cell instance gf180mcu_fd_sc_mcu9t5v0__inv_2_2 r0 *1 0,0
Xgf180mcu_fd_sc_mcu9t5v0__inv_2_2 rxdp VDD VSS vsubs VSS u_line_state/_2_
+ gf180mcu_fd_sc_mcu9t5v0__inv_2
* cell instance gf180mcu_fd_sc_mcu9t5v0__inv_3_0 r0 *1 0,0
Xgf180mcu_fd_sc_mcu9t5v0__inv_3_0 \_054_ VDD
+ gf180mcu_fd_sc_mcu9t5v0__inv_3_0__VNW vsubs VSS \_055_
+ gf180mcu_fd_sc_mcu9t5v0__inv_3
* cell instance gf180mcu_fd_sc_mcu9t5v0__inv_3_1 r0 *1 0,0
Xgf180mcu_fd_sc_mcu9t5v0__inv_3_1 u_stuffer/run[0] VDD VSS vsubs VSS
+ u_stuffer/_03_ gf180mcu_fd_sc_mcu9t5v0__inv_3
* cell instance gf180mcu_fd_sc_mcu9t5v0__inv_4_0 r0 *1 0,0
Xgf180mcu_fd_sc_mcu9t5v0__inv_4_0 clknet_3_2__leaf_clk VDD clknet_0_clk vsubs
+ VSS \$771 gf180mcu_fd_sc_mcu9t5v0__inv_4
* cell instance gf180mcu_fd_sc_mcu9t5v0__inv_4_1 r0 *1 0,0
Xgf180mcu_fd_sc_mcu9t5v0__inv_4_1 clknet_3_1__leaf_clk VDD \_056_ vsubs VSS
+ \$357 gf180mcu_fd_sc_mcu9t5v0__inv_4
* cell instance gf180mcu_fd_sc_mcu9t5v0__inv_4_2 r0 *1 0,0
Xgf180mcu_fd_sc_mcu9t5v0__inv_4_2 clknet_3_3__leaf_clk VDD clknet_3_3__leaf_clk
+ vsubs VSS \$797 gf180mcu_fd_sc_mcu9t5v0__inv_4
* cell instance gf180mcu_fd_sc_mcu9t5v0__inv_4_3 r0 *1 0,0
Xgf180mcu_fd_sc_mcu9t5v0__inv_4_3 clknet_3_6__leaf_clk VDD
+ gf180mcu_fd_sc_mcu9t5v0__inv_4_3__VNW vsubs VSS \$893
+ gf180mcu_fd_sc_mcu9t5v0__inv_4
* cell instance gf180mcu_fd_sc_mcu9t5v0__inv_4_4 r0 *1 0,0
Xgf180mcu_fd_sc_mcu9t5v0__inv_4_4 tx_state[1] VDD \_095_ vsubs VSS \_065_
+ gf180mcu_fd_sc_mcu9t5v0__inv_4
* cell instance gf180mcu_fd_sc_mcu9t5v0__inv_8_0 r0 *1 0,0
Xgf180mcu_fd_sc_mcu9t5v0__inv_8_0 clknet_3_4__leaf_clk VDD VSS vsubs VSS \$432
+ gf180mcu_fd_sc_mcu9t5v0__inv_8
* cell instance gf180mcu_fd_sc_mcu9t5v0__mux2_1_0 r0 *1 0,0
Xgf180mcu_fd_sc_mcu9t5v0__mux2_1_0 DataIn[4] rx_shift[5] \_101_ VDD
+ gf180mcu_fd_sc_mcu9t5v0__mux2_1_0__VNW vsubs VSS \_035_
+ gf180mcu_fd_sc_mcu9t5v0__mux2_1
* cell instance gf180mcu_fd_sc_mcu9t5v0__mux2_1_1 r0 *1 0,0
Xgf180mcu_fd_sc_mcu9t5v0__mux2_1_1 DataIn[3] rx_shift[4] \_101_ VDD
+ gf180mcu_fd_sc_mcu9t5v0__mux2_1_1__VNW vsubs VSS \_036_
+ gf180mcu_fd_sc_mcu9t5v0__mux2_1
* cell instance gf180mcu_fd_sc_mcu9t5v0__mux2_1_2 r0 *1 0,0
Xgf180mcu_fd_sc_mcu9t5v0__mux2_1_2 DataIn[2] rx_shift[3] \_101_ VDD
+ gf180mcu_fd_sc_mcu9t5v0__mux2_1_2__VNW vsubs VSS \_038_
+ gf180mcu_fd_sc_mcu9t5v0__mux2_1
* cell instance gf180mcu_fd_sc_mcu9t5v0__mux2_1_3 r0 *1 0,0
Xgf180mcu_fd_sc_mcu9t5v0__mux2_1_3 DataIn[5] rx_shift[6] \_101_ VDD
+ gf180mcu_fd_sc_mcu9t5v0__mux2_1_3__VNW vsubs VSS \_034_
+ gf180mcu_fd_sc_mcu9t5v0__mux2_1
* cell instance gf180mcu_fd_sc_mcu9t5v0__mux2_1_4 r0 *1 0,0
Xgf180mcu_fd_sc_mcu9t5v0__mux2_1_4 DataIn[1] rx_shift[2] \_101_ VDD DataIn[2]
+ vsubs VSS \_013_ gf180mcu_fd_sc_mcu9t5v0__mux2_1
* cell instance gf180mcu_fd_sc_mcu9t5v0__mux2_1_5 r0 *1 0,0
Xgf180mcu_fd_sc_mcu9t5v0__mux2_1_5 DataIn[0] rx_shift[1] \_101_ VDD
+ gf180mcu_fd_sc_mcu9t5v0__mux2_1_5__VNW vsubs VSS \_015_
+ gf180mcu_fd_sc_mcu9t5v0__mux2_1
* cell instance gf180mcu_fd_sc_mcu9t5v0__mux2_1_6 r0 *1 0,0
Xgf180mcu_fd_sc_mcu9t5v0__mux2_1_6 DataIn[7] rx_out_bit \_101_ VDD VSS vsubs
+ VSS \_037_ gf180mcu_fd_sc_mcu9t5v0__mux2_1
* cell instance gf180mcu_fd_sc_mcu9t5v0__mux2_1_7 r0 *1 0,0
Xgf180mcu_fd_sc_mcu9t5v0__mux2_1_7 DataIn[6] rx_shift[7] \_101_ VDD
+ gf180mcu_fd_sc_mcu9t5v0__mux2_1_7__VNW vsubs VSS \_033_
+ gf180mcu_fd_sc_mcu9t5v0__mux2_1
* cell instance gf180mcu_fd_sc_mcu9t5v0__mux2_1_8 r0 *1 0,0
Xgf180mcu_fd_sc_mcu9t5v0__mux2_1_8 \_009_ u_decoder/prev_level u_decoder/_04_
+ VDD gf180mcu_fd_sc_mcu9t5v0__mux2_1_8__VNW vsubs VSS u_decoder/_01_
+ gf180mcu_fd_sc_mcu9t5v0__mux2_1
* cell instance gf180mcu_fd_sc_mcu9t5v0__mux2_2_0 r0 *1 0,0
Xgf180mcu_fd_sc_mcu9t5v0__mux2_2_0 rx_out_bit dec_data_bit u_destuffer/_00_ VDD
+ \_002_ vsubs VSS u_destuffer/_03_ gf180mcu_fd_sc_mcu9t5v0__mux2_2
* cell instance gf180mcu_fd_sc_mcu9t5v0__mux2_2_1 r0 *1 0,0
Xgf180mcu_fd_sc_mcu9t5v0__mux2_2_1 u_decoder/_03_ dec_data_bit u_decoder/_04_
+ VDD VSS vsubs VSS u_decoder/_02_ gf180mcu_fd_sc_mcu9t5v0__mux2_2
* cell instance gf180mcu_fd_sc_mcu9t5v0__mux2_2_2 r0 *1 0,0
Xgf180mcu_fd_sc_mcu9t5v0__mux2_2_2 nrzi_level u_encoder/_2_ \_006_ VDD
+ gf180mcu_fd_sc_mcu9t5v0__mux2_2_2__VNW vsubs VSS u_encoder/_0_
+ gf180mcu_fd_sc_mcu9t5v0__mux2_2
* cell instance gf180mcu_fd_sc_mcu9t5v0__mux4_1_0 r0 *1 0,0
Xgf180mcu_fd_sc_mcu9t5v0__mux4_1_0 byte_reg[2] byte_reg[3] byte_reg[6]
+ byte_reg[7] byte_idx[0] byte_idx[2] VDD byte_reg[6] vsubs VSS \_078_
+ gf180mcu_fd_sc_mcu9t5v0__mux4_1
* cell instance gf180mcu_fd_sc_mcu9t5v0__nand2_1_0 r0 *1 0,0
Xgf180mcu_fd_sc_mcu9t5v0__nand2_1_0 rx_shift[5] \_099_ VDD
+ gf180mcu_fd_sc_mcu9t5v0__nand2_1_0__VNW vsubs VSS \_115_
+ gf180mcu_fd_sc_mcu9t5v0__nand2_1
* cell instance gf180mcu_fd_sc_mcu9t5v0__nand2_1_1 r0 *1 0,0
Xgf180mcu_fd_sc_mcu9t5v0__nand2_1_1 rx_shift[4] \_112_ VDD
+ gf180mcu_fd_sc_mcu9t5v0__nand2_1_1__VNW vsubs VSS \_113_
+ gf180mcu_fd_sc_mcu9t5v0__nand2_1
* cell instance gf180mcu_fd_sc_mcu9t5v0__nand2_1_2 r0 *1 0,0
Xgf180mcu_fd_sc_mcu9t5v0__nand2_1_2 rx_shift[5] \_112_ VDD \_128_ vsubs VSS
+ \_128_ gf180mcu_fd_sc_mcu9t5v0__nand2_1
* cell instance gf180mcu_fd_sc_mcu9t5v0__nand2_1_3 r0 *1 0,0
Xgf180mcu_fd_sc_mcu9t5v0__nand2_1_3 rx_shift[6] \_099_ VDD VSS vsubs VSS \_129_
+ gf180mcu_fd_sc_mcu9t5v0__nand2_1
* cell instance gf180mcu_fd_sc_mcu9t5v0__nand2_1_4 r0 *1 0,0
Xgf180mcu_fd_sc_mcu9t5v0__nand2_1_4 rx_shift[4] \_099_ VDD
+ gf180mcu_fd_sc_mcu9t5v0__nand2_1_4__VNW vsubs VSS \_117_
+ gf180mcu_fd_sc_mcu9t5v0__nand2_1
* cell instance gf180mcu_fd_sc_mcu9t5v0__nand2_1_5 r0 *1 0,0
Xgf180mcu_fd_sc_mcu9t5v0__nand2_1_5 rx_shift[3] \_112_ VDD \_116_ vsubs VSS
+ \_116_ gf180mcu_fd_sc_mcu9t5v0__nand2_1
* cell instance gf180mcu_fd_sc_mcu9t5v0__nand2_1_6 r0 *1 0,0
Xgf180mcu_fd_sc_mcu9t5v0__nand2_1_6 rx_shift[6] \_112_ VDD
+ gf180mcu_fd_sc_mcu9t5v0__nand2_1_6__VNW vsubs VSS \_124_
+ gf180mcu_fd_sc_mcu9t5v0__nand2_1
* cell instance gf180mcu_fd_sc_mcu9t5v0__nand2_1_7 r0 *1 0,0
Xgf180mcu_fd_sc_mcu9t5v0__nand2_1_7 rx_shift[3] \_099_ VDD
+ gf180mcu_fd_sc_mcu9t5v0__nand2_1_7__VNW vsubs VSS \_121_
+ gf180mcu_fd_sc_mcu9t5v0__nand2_1
* cell instance gf180mcu_fd_sc_mcu9t5v0__nand2_1_8 r0 *1 0,0
Xgf180mcu_fd_sc_mcu9t5v0__nand2_1_8 rx_shift[7] \_099_ VDD \_125_ vsubs VSS
+ \_125_ gf180mcu_fd_sc_mcu9t5v0__nand2_1
* cell instance gf180mcu_fd_sc_mcu9t5v0__nand2_1_9 r0 *1 0,0
Xgf180mcu_fd_sc_mcu9t5v0__nand2_1_9 rx_bit_valid rx_assembly_en VDD
+ gf180mcu_fd_sc_mcu9t5v0__nand2_1_9__VNW vsubs VSS \_112_
+ gf180mcu_fd_sc_mcu9t5v0__nand2_1
* cell instance gf180mcu_fd_sc_mcu9t5v0__nand2_1_10 r0 *1 0,0
Xgf180mcu_fd_sc_mcu9t5v0__nand2_1_10 rx_shift[2] \_112_ VDD \_120_ vsubs VSS
+ \_120_ gf180mcu_fd_sc_mcu9t5v0__nand2_1
* cell instance gf180mcu_fd_sc_mcu9t5v0__nand2_1_11 r0 *1 0,0
Xgf180mcu_fd_sc_mcu9t5v0__nand2_1_11 rx_out_bit \_099_ VDD
+ gf180mcu_fd_sc_mcu9t5v0__nand2_1_11__VNW vsubs VSS \_155_
+ gf180mcu_fd_sc_mcu9t5v0__nand2_1
* cell instance gf180mcu_fd_sc_mcu9t5v0__nand2_1_12 r0 *1 0,0
Xgf180mcu_fd_sc_mcu9t5v0__nand2_1_12 rx_shift[7] \_112_ VDD
+ gf180mcu_fd_sc_mcu9t5v0__nand2_1_12__VNW vsubs VSS \_154_
+ gf180mcu_fd_sc_mcu9t5v0__nand2_1
* cell instance gf180mcu_fd_sc_mcu9t5v0__nand2_1_13 r0 *1 0,0
Xgf180mcu_fd_sc_mcu9t5v0__nand2_1_13 rx_shift[2] \_099_ VDD
+ gf180mcu_fd_sc_mcu9t5v0__nand2_1_13__VNW vsubs VSS \_123_
+ gf180mcu_fd_sc_mcu9t5v0__nand2_1
* cell instance gf180mcu_fd_sc_mcu9t5v0__nand2_1_14 r0 *1 0,0
Xgf180mcu_fd_sc_mcu9t5v0__nand2_1_14 rx_shift[1] \_112_ VDD
+ gf180mcu_fd_sc_mcu9t5v0__nand2_1_14__VNW vsubs VSS \_122_
+ gf180mcu_fd_sc_mcu9t5v0__nand2_1
* cell instance gf180mcu_fd_sc_mcu9t5v0__nand2_1_15 r0 *1 0,0
Xgf180mcu_fd_sc_mcu9t5v0__nand2_1_15 txoe \_068_ VDD DataIn[2] vsubs VSS
+ TxReady gf180mcu_fd_sc_mcu9t5v0__nand2_1
* cell instance gf180mcu_fd_sc_mcu9t5v0__nand2_1_16 r0 *1 0,0
Xgf180mcu_fd_sc_mcu9t5v0__nand2_1_16 u_line_state/_2_ \_055_ VDD VSS vsubs VSS
+ u_line_state/_0_ gf180mcu_fd_sc_mcu9t5v0__nand2_1
* cell instance gf180mcu_fd_sc_mcu9t5v0__nand2_1_17 r0 *1 0,0
Xgf180mcu_fd_sc_mcu9t5v0__nand2_1_17 \_055_ u_eop_detector/_08_ VDD
+ gf180mcu_fd_sc_mcu9t5v0__nand2_1_17__VNW vsubs VSS u_eop_detector/_09_
+ gf180mcu_fd_sc_mcu9t5v0__nand2_1
* cell instance gf180mcu_fd_sc_mcu9t5v0__nand2_1_18 r0 *1 0,0
Xgf180mcu_fd_sc_mcu9t5v0__nand2_1_18 \_055_ \_075_ VDD
+ gf180mcu_fd_sc_mcu9t5v0__nand2_1_18__VNW vsubs VSS \_007_
+ gf180mcu_fd_sc_mcu9t5v0__nand2_1
* cell instance gf180mcu_fd_sc_mcu9t5v0__nand2_1_19 r0 *1 0,0
Xgf180mcu_fd_sc_mcu9t5v0__nand2_1_19 TxValid \_052_ VDD VSS vsubs VSS \_075_
+ gf180mcu_fd_sc_mcu9t5v0__nand2_1
* cell instance gf180mcu_fd_sc_mcu9t5v0__nand2_1_20 r0 *1 0,0
Xgf180mcu_fd_sc_mcu9t5v0__nand2_1_20 u_eop_detector/se0_count[1]
+ u_eop_detector/_10_ VDD VSS vsubs VSS u_eop_detector/_20_
+ gf180mcu_fd_sc_mcu9t5v0__nand2_1
* cell instance gf180mcu_fd_sc_mcu9t5v0__nand2_1_21 r0 *1 0,0
Xgf180mcu_fd_sc_mcu9t5v0__nand2_1_21 \_055_ \_077_ VDD VDD vsubs VSS \_005_
+ gf180mcu_fd_sc_mcu9t5v0__nand2_1
* cell instance gf180mcu_fd_sc_mcu9t5v0__nand2_1_22 r0 *1 0,0
Xgf180mcu_fd_sc_mcu9t5v0__nand2_1_22 u_eop_detector/_17_
+ u_eop_detector/se0_count[0] VDD VDD vsubs VSS u_eop_detector/_18_
+ gf180mcu_fd_sc_mcu9t5v0__nand2_1
* cell instance gf180mcu_fd_sc_mcu9t5v0__nand2_1_23 r0 *1 0,0
Xgf180mcu_fd_sc_mcu9t5v0__nand2_1_23 stuff_consume \_067_ VDD VDD vsubs VSS
+ \_068_ gf180mcu_fd_sc_mcu9t5v0__nand2_1
* cell instance gf180mcu_fd_sc_mcu9t5v0__nand2_1_24 r0 *1 0,0
Xgf180mcu_fd_sc_mcu9t5v0__nand2_1_24 first_byte \_102_ VDD byte_idx[2] vsubs
+ VSS \_104_ gf180mcu_fd_sc_mcu9t5v0__nand2_1
* cell instance gf180mcu_fd_sc_mcu9t5v0__nand2_1_25 r0 *1 0,0
Xgf180mcu_fd_sc_mcu9t5v0__nand2_1_25 stuff_bit_out \_072_ VDD
+ gf180mcu_fd_sc_mcu9t5v0__nand2_1_25__VNW vsubs VSS \_074_
+ gf180mcu_fd_sc_mcu9t5v0__nand2_1
* cell instance gf180mcu_fd_sc_mcu9t5v0__nand2_1_26 r0 *1 0,0
Xgf180mcu_fd_sc_mcu9t5v0__nand2_1_26 byte_reg[0] \_080_ VDD
+ gf180mcu_fd_sc_mcu9t5v0__nand2_1_26__VNW vsubs VSS \_081_
+ gf180mcu_fd_sc_mcu9t5v0__nand2_1
* cell instance gf180mcu_fd_sc_mcu9t5v0__nand2_1_27 r0 *1 0,0
Xgf180mcu_fd_sc_mcu9t5v0__nand2_1_27 first_byte \_080_ VDD \_077_ vsubs VSS
+ \_090_ gf180mcu_fd_sc_mcu9t5v0__nand2_1
* cell instance gf180mcu_fd_sc_mcu9t5v0__nand2_1_28 r0 *1 0,0
Xgf180mcu_fd_sc_mcu9t5v0__nand2_1_28 \_069_ \_071_ VDD \_072_ vsubs VSS \_072_
+ gf180mcu_fd_sc_mcu9t5v0__nand2_1
* cell instance gf180mcu_fd_sc_mcu9t5v0__nand2_1_29 r0 *1 0,0
Xgf180mcu_fd_sc_mcu9t5v0__nand2_1_29 \_070_ \_052_ VDD
+ gf180mcu_fd_sc_mcu9t5v0__nand2_1_29__VNW vsubs VSS \_071_
+ gf180mcu_fd_sc_mcu9t5v0__nand2_1
* cell instance gf180mcu_fd_sc_mcu9t5v0__nand2_1_30 r0 *1 0,0
Xgf180mcu_fd_sc_mcu9t5v0__nand2_1_30 tx_state[0] \_069_ VDD
+ gf180mcu_fd_sc_mcu9t5v0__nand2_1_30__VNW vsubs VSS \_132_
+ gf180mcu_fd_sc_mcu9t5v0__nand2_1
* cell instance gf180mcu_fd_sc_mcu9t5v0__nand2_1_31 r0 *1 0,0
Xgf180mcu_fd_sc_mcu9t5v0__nand2_1_31 \_060_ tx_state[1] VDD
+ gf180mcu_fd_sc_mcu9t5v0__nand2_1_31__VNW vsubs VSS \_077_
+ gf180mcu_fd_sc_mcu9t5v0__nand2_1
* cell instance gf180mcu_fd_sc_mcu9t5v0__nand2_1_32 r0 *1 0,0
Xgf180mcu_fd_sc_mcu9t5v0__nand2_1_32 sync_idx[0] sync_idx[1] VDD
+ gf180mcu_fd_sc_mcu9t5v0__nand2_1_32__VNW vsubs VSS \_131_
+ gf180mcu_fd_sc_mcu9t5v0__nand2_1
* cell instance gf180mcu_fd_sc_mcu9t5v0__nand2_1_33 r0 *1 0,0
Xgf180mcu_fd_sc_mcu9t5v0__nand2_1_33 byte_idx[0] byte_idx[1] VDD
+ gf180mcu_fd_sc_mcu9t5v0__nand2_1_33__VNW vsubs VSS \_108_
+ gf180mcu_fd_sc_mcu9t5v0__nand2_1
* cell instance gf180mcu_fd_sc_mcu9t5v0__nand2_1_34 r0 *1 0,0
Xgf180mcu_fd_sc_mcu9t5v0__nand2_1_34 tx_state[2] \_064_ VDD \_064_ vsubs VSS
+ \_158_ gf180mcu_fd_sc_mcu9t5v0__nand2_1
* cell instance gf180mcu_fd_sc_mcu9t5v0__nand2_1_35 r0 *1 0,0
Xgf180mcu_fd_sc_mcu9t5v0__nand2_1_35 tx_state[0] tx_state[1] VDD
+ gf180mcu_fd_sc_mcu9t5v0__nand2_1_35__VNW vsubs VSS \_064_
+ gf180mcu_fd_sc_mcu9t5v0__nand2_1
* cell instance gf180mcu_fd_sc_mcu9t5v0__nand2_2_0 r0 *1 0,0
Xgf180mcu_fd_sc_mcu9t5v0__nand2_2_0 u_stuffer/run[0] \_005_ VDD u_stuffer/_11_
+ vsubs VSS u_stuffer/_10_ gf180mcu_fd_sc_mcu9t5v0__nand2_2
* cell instance gf180mcu_fd_sc_mcu9t5v0__nand2_4_0 r0 *1 0,0
Xgf180mcu_fd_sc_mcu9t5v0__nand2_4_0 u_destuffer/ones_run[1]
+ u_destuffer/ones_run[2] VDD VSS vsubs VSS u_destuffer/_06_
+ gf180mcu_fd_sc_mcu9t5v0__nand2_4
* cell instance gf180mcu_fd_sc_mcu9t5v0__nand2_4_1 r0 *1 0,0
Xgf180mcu_fd_sc_mcu9t5v0__nand2_4_1 rx_dec_strobe dec_data_bit VDD
+ gf180mcu_fd_sc_mcu9t5v0__nand2_4_1__VNW vsubs VSS u_sync_detector/_07_
+ gf180mcu_fd_sc_mcu9t5v0__nand2_4
* cell instance gf180mcu_fd_sc_mcu9t5v0__nand2_4_2 r0 *1 0,0
Xgf180mcu_fd_sc_mcu9t5v0__nand2_4_2 rx_receiving \_055_ VDD VSS vsubs VSS
+ \_056_ gf180mcu_fd_sc_mcu9t5v0__nand2_4
* cell instance gf180mcu_fd_sc_mcu9t5v0__nand2_4_3 r0 *1 0,0
Xgf180mcu_fd_sc_mcu9t5v0__nand2_4_3 rst_n \_053_ VDD DataIn[0] vsubs VSS \_054_
+ gf180mcu_fd_sc_mcu9t5v0__nand2_4
* cell instance gf180mcu_fd_sc_mcu9t5v0__nand2_4_4 r0 *1 0,0
Xgf180mcu_fd_sc_mcu9t5v0__nand2_4_4 \_008_ \_008_ VDD
+ gf180mcu_fd_sc_mcu9t5v0__nand2_4_4__VNW vsubs VSS u_decoder/_04_
+ gf180mcu_fd_sc_mcu9t5v0__nand2_4
* cell instance gf180mcu_fd_sc_mcu9t5v0__nand3_1_0 r0 *1 0,0
Xgf180mcu_fd_sc_mcu9t5v0__nand3_1_0 u_eop_detector/se0_count[3]
+ u_eop_detector/se0_count[2] u_eop_detector/_15_ VDD
+ u_eop_detector/se0_count[2] vsubs VSS u_eop_detector/_23_
+ gf180mcu_fd_sc_mcu9t5v0__nand3_1
* cell instance gf180mcu_fd_sc_mcu9t5v0__nand3_1_1 r0 *1 0,0
Xgf180mcu_fd_sc_mcu9t5v0__nand3_1_1 u_stuffer/_07_ \_010_ \_005_ VDD VSS vsubs
+ VSS u_stuffer/_08_ gf180mcu_fd_sc_mcu9t5v0__nand3_1
* cell instance gf180mcu_fd_sc_mcu9t5v0__nand3_1_2 r0 *1 0,0
Xgf180mcu_fd_sc_mcu9t5v0__nand3_1_2 u_stuffer/run[2] \_010_ u_stuffer/_04_ VDD
+ VDD vsubs VSS u_stuffer/_05_ gf180mcu_fd_sc_mcu9t5v0__nand3_1
* cell instance gf180mcu_fd_sc_mcu9t5v0__nand3_1_3 r0 *1 0,0
Xgf180mcu_fd_sc_mcu9t5v0__nand3_1_3 \_055_ \_073_ \_091_ VDD \_133_ vsubs VSS
+ \_145_ gf180mcu_fd_sc_mcu9t5v0__nand3_1
* cell instance gf180mcu_fd_sc_mcu9t5v0__nand3_1_4 r0 *1 0,0
Xgf180mcu_fd_sc_mcu9t5v0__nand3_1_4 sync_idx[2] sync_idx[0] sync_idx[1] VDD
+ gf180mcu_fd_sc_mcu9t5v0__nand3_1_4__VNW vsubs VSS \_073_
+ gf180mcu_fd_sc_mcu9t5v0__nand3_1
* cell instance gf180mcu_fd_sc_mcu9t5v0__nand3_1_5 r0 *1 0,0
Xgf180mcu_fd_sc_mcu9t5v0__nand3_1_5 \_107_ \_108_ \_082_ VDD
+ gf180mcu_fd_sc_mcu9t5v0__nand3_1_5__VNW vsubs VSS \_109_
+ gf180mcu_fd_sc_mcu9t5v0__nand3_1
* cell instance gf180mcu_fd_sc_mcu9t5v0__nand3_1_6 r0 *1 0,0
Xgf180mcu_fd_sc_mcu9t5v0__nand3_1_6 \_084_ \_055_ \_143_ VDD
+ gf180mcu_fd_sc_mcu9t5v0__nand3_1_6__VNW vsubs VSS \_144_
+ gf180mcu_fd_sc_mcu9t5v0__nand3_1
* cell instance gf180mcu_fd_sc_mcu9t5v0__nand3_1_7 r0 *1 0,0
Xgf180mcu_fd_sc_mcu9t5v0__nand3_1_7 \_135_ \_136_ \_137_ VDD \_064_ vsubs VSS
+ \_138_ gf180mcu_fd_sc_mcu9t5v0__nand3_1
* cell instance gf180mcu_fd_sc_mcu9t5v0__nand3_2_0 r0 *1 0,0
Xgf180mcu_fd_sc_mcu9t5v0__nand3_2_0 u_stuffer/run[1] u_stuffer/run[0] \_005_
+ VDD gf180mcu_fd_sc_mcu9t5v0__nand3_2_0__VNW vsubs VSS u_stuffer/_12_
+ gf180mcu_fd_sc_mcu9t5v0__nand3_2
* cell instance gf180mcu_fd_sc_mcu9t5v0__nand3_2_1 r0 *1 0,0
Xgf180mcu_fd_sc_mcu9t5v0__nand3_2_1 \_010_ u_stuffer/_04_ stuff_consume VDD
+ gf180mcu_fd_sc_mcu9t5v0__nand3_2_1__VNW vsubs VSS u_stuffer/_09_
+ gf180mcu_fd_sc_mcu9t5v0__nand3_2
* cell instance gf180mcu_fd_sc_mcu9t5v0__nand3_2_2 r0 *1 0,0
Xgf180mcu_fd_sc_mcu9t5v0__nand3_2_2 \_060_ \_084_ tx_state[1] VDD VSS vsubs VSS
+ \_089_ gf180mcu_fd_sc_mcu9t5v0__nand3_2
* cell instance gf180mcu_fd_sc_mcu9t5v0__nand3_4_0 r0 *1 0,0
Xgf180mcu_fd_sc_mcu9t5v0__nand3_4_0 u_sync_detector/match[0]
+ u_sync_detector/match[1] u_sync_detector/match[2] VDD
+ gf180mcu_fd_sc_mcu9t5v0__nand3_4_0__VNW vsubs VSS u_sync_detector/_06_
+ gf180mcu_fd_sc_mcu9t5v0__nand3_4
* cell instance gf180mcu_fd_sc_mcu9t5v0__nand3_4_1 r0 *1 0,0
Xgf180mcu_fd_sc_mcu9t5v0__nand3_4_1 \_004_ \_055_ u_sync_detector/_07_ VDD
+ gf180mcu_fd_sc_mcu9t5v0__nand3_4_1__VNW vsubs VSS u_sync_detector/_09_
+ gf180mcu_fd_sc_mcu9t5v0__nand3_4
* cell instance gf180mcu_fd_sc_mcu9t5v0__nand3_4_2 r0 *1 0,0
Xgf180mcu_fd_sc_mcu9t5v0__nand3_4_2 byte_idx[0] byte_idx[1] byte_idx[2] VDD VSS
+ vsubs VSS \_066_ gf180mcu_fd_sc_mcu9t5v0__nand3_4
* cell instance gf180mcu_fd_sc_mcu9t5v0__nand4_1_0 r0 *1 0,0
Xgf180mcu_fd_sc_mcu9t5v0__nand4_1_0 \_060_ \_084_ tx_state[1] \_066_ VDD VDD
+ vsubs VSS \_097_ gf180mcu_fd_sc_mcu9t5v0__nand4_1
* cell instance gf180mcu_fd_sc_mcu9t5v0__nand4_1_1 r0 *1 0,0
Xgf180mcu_fd_sc_mcu9t5v0__nand4_1_1 byte_idx[0] byte_idx[1] \_093_ \_095_ VDD
+ VDD vsubs VSS \_096_ gf180mcu_fd_sc_mcu9t5v0__nand4_1
* cell instance gf180mcu_fd_sc_mcu9t5v0__nand4_4_0 r0 *1 0,0
Xgf180mcu_fd_sc_mcu9t5v0__nand4_4_0 u_stuffer/run[1] u_stuffer/_03_
+ u_stuffer/run[2] u_stuffer/_04_ VDD gf180mcu_fd_sc_mcu9t5v0__nand4_4_0__VNW
+ vsubs VSS stuff_consume gf180mcu_fd_sc_mcu9t5v0__nand4_4
* cell instance gf180mcu_fd_sc_mcu9t5v0__nor2_1_0 r0 *1 0,0
Xgf180mcu_fd_sc_mcu9t5v0__nor2_1_0 u_destuffer/_10_ u_destuffer/_14_ VDD
+ gf180mcu_fd_sc_mcu9t5v0__nor2_1_0__VNW vsubs VSS u_destuffer/_04_
+ gf180mcu_fd_sc_mcu9t5v0__nor2_1
* cell instance gf180mcu_fd_sc_mcu9t5v0__nor2_1_1 r0 *1 0,0
Xgf180mcu_fd_sc_mcu9t5v0__nor2_1_1 u_destuffer/_12_ u_destuffer/_15_ VDD
+ gf180mcu_fd_sc_mcu9t5v0__nor2_1_1__VNW vsubs VSS u_destuffer/_05_
+ gf180mcu_fd_sc_mcu9t5v0__nor2_1
* cell instance gf180mcu_fd_sc_mcu9t5v0__nor2_1_2 r0 *1 0,0
Xgf180mcu_fd_sc_mcu9t5v0__nor2_1_2 u_sync_detector/match[1]
+ u_sync_detector/_13_ VDD gf180mcu_fd_sc_mcu9t5v0__nor2_1_2__VNW vsubs VSS
+ u_sync_detector/_14_ gf180mcu_fd_sc_mcu9t5v0__nor2_1
* cell instance gf180mcu_fd_sc_mcu9t5v0__nor2_1_3 r0 *1 0,0
Xgf180mcu_fd_sc_mcu9t5v0__nor2_1_3 u_sync_detector/match[0] rx_dec_strobe VDD
+ gf180mcu_fd_sc_mcu9t5v0__nor2_1_3__VNW vsubs VSS u_sync_detector/_15_
+ gf180mcu_fd_sc_mcu9t5v0__nor2_1
* cell instance gf180mcu_fd_sc_mcu9t5v0__nor2_1_4 r0 *1 0,0
Xgf180mcu_fd_sc_mcu9t5v0__nor2_1_4 u_sync_detector/match[2]
+ u_sync_detector/_10_ VDD gf180mcu_fd_sc_mcu9t5v0__nor2_1_4__VNW vsubs VSS
+ u_sync_detector/_12_ gf180mcu_fd_sc_mcu9t5v0__nor2_1
* cell instance gf180mcu_fd_sc_mcu9t5v0__nor2_1_5 r0 *1 0,0
Xgf180mcu_fd_sc_mcu9t5v0__nor2_1_5 DataOut[6] \_102_ VDD DataOut[6] vsubs VSS
+ \_147_ gf180mcu_fd_sc_mcu9t5v0__nor2_1
* cell instance gf180mcu_fd_sc_mcu9t5v0__nor2_1_6 r0 *1 0,0
Xgf180mcu_fd_sc_mcu9t5v0__nor2_1_6 sync_next \_118_ VDD
+ gf180mcu_fd_sc_mcu9t5v0__nor2_1_6__VNW vsubs VSS \_119_
+ gf180mcu_fd_sc_mcu9t5v0__nor2_1
* cell instance gf180mcu_fd_sc_mcu9t5v0__nor2_1_7 r0 *1 0,0
Xgf180mcu_fd_sc_mcu9t5v0__nor2_1_7 \_054_ \_119_ VDD \_054_ vsubs VSS \_021_
+ gf180mcu_fd_sc_mcu9t5v0__nor2_1
* cell instance gf180mcu_fd_sc_mcu9t5v0__nor2_1_8 r0 *1 0,0
Xgf180mcu_fd_sc_mcu9t5v0__nor2_1_8 DataOut[4] \_102_ VDD DataOut[4] vsubs VSS
+ \_151_ gf180mcu_fd_sc_mcu9t5v0__nor2_1
* cell instance gf180mcu_fd_sc_mcu9t5v0__nor2_1_9 r0 *1 0,0
Xgf180mcu_fd_sc_mcu9t5v0__nor2_1_9 \_057_ rx_dec_mask VDD rx_dec_mask vsubs VSS
+ rx_dec_strobe gf180mcu_fd_sc_mcu9t5v0__nor2_1
* cell instance gf180mcu_fd_sc_mcu9t5v0__nor2_1_10 r0 *1 0,0
Xgf180mcu_fd_sc_mcu9t5v0__nor2_1_10 line_state[0] line_state[1] VDD
+ gf180mcu_fd_sc_mcu9t5v0__nor2_1_10__VNW vsubs VSS u_eop_detector/_08_
+ gf180mcu_fd_sc_mcu9t5v0__nor2_1
* cell instance gf180mcu_fd_sc_mcu9t5v0__nor2_1_11 r0 *1 0,0
Xgf180mcu_fd_sc_mcu9t5v0__nor2_1_11 DataOut[3] \_102_ VDD DataOut[3] vsubs VSS
+ \_153_ gf180mcu_fd_sc_mcu9t5v0__nor2_1
* cell instance gf180mcu_fd_sc_mcu9t5v0__nor2_1_12 r0 *1 0,0
Xgf180mcu_fd_sc_mcu9t5v0__nor2_1_12 DataOut[2] \_102_ VDD DataOut[2] vsubs VSS
+ \_157_ gf180mcu_fd_sc_mcu9t5v0__nor2_1
* cell instance gf180mcu_fd_sc_mcu9t5v0__nor2_1_13 r0 *1 0,0
Xgf180mcu_fd_sc_mcu9t5v0__nor2_1_13 u_eop_detector/_09_ u_eop_detector/_13_ VDD
+ gf180mcu_fd_sc_mcu9t5v0__nor2_1_13__VNW vsubs VSS u_eop_detector/_00_
+ gf180mcu_fd_sc_mcu9t5v0__nor2_1
* cell instance gf180mcu_fd_sc_mcu9t5v0__nor2_1_14 r0 *1 0,0
Xgf180mcu_fd_sc_mcu9t5v0__nor2_1_14 \_076_ OpMode[0] VDD VSS vsubs VSS raw_mode
+ gf180mcu_fd_sc_mcu9t5v0__nor2_1
* cell instance gf180mcu_fd_sc_mcu9t5v0__nor2_1_15 r0 *1 0,0
Xgf180mcu_fd_sc_mcu9t5v0__nor2_1_15 DataOut[0] \_102_ VDD DataOut[0] vsubs VSS
+ \_163_ gf180mcu_fd_sc_mcu9t5v0__nor2_1
* cell instance gf180mcu_fd_sc_mcu9t5v0__nor2_1_16 r0 *1 0,0
Xgf180mcu_fd_sc_mcu9t5v0__nor2_1_16 u_eop_detector/_17_ u_eop_detector/_09_ VDD
+ u_eop_detector/_09_ vsubs VSS u_eop_detector/_06_
+ gf180mcu_fd_sc_mcu9t5v0__nor2_1
* cell instance gf180mcu_fd_sc_mcu9t5v0__nor2_1_17 r0 *1 0,0
Xgf180mcu_fd_sc_mcu9t5v0__nor2_1_17 DataOut[1] \_102_ VDD DataOut[1] vsubs VSS
+ \_160_ gf180mcu_fd_sc_mcu9t5v0__nor2_1
* cell instance gf180mcu_fd_sc_mcu9t5v0__nor2_1_18 r0 *1 0,0
Xgf180mcu_fd_sc_mcu9t5v0__nor2_1_18 DataOut[5] \_102_ VDD DataOut[5] vsubs VSS
+ \_149_ gf180mcu_fd_sc_mcu9t5v0__nor2_1
* cell instance gf180mcu_fd_sc_mcu9t5v0__nor2_1_19 r0 *1 0,0
Xgf180mcu_fd_sc_mcu9t5v0__nor2_1_19 \_060_ \_062_ VDD VSS vsubs VSS \_063_
+ gf180mcu_fd_sc_mcu9t5v0__nor2_1
* cell instance gf180mcu_fd_sc_mcu9t5v0__nor2_1_20 r0 *1 0,0
Xgf180mcu_fd_sc_mcu9t5v0__nor2_1_20 \_130_ \_133_ VDD
+ gf180mcu_fd_sc_mcu9t5v0__nor2_1_20__VNW vsubs VSS \_028_
+ gf180mcu_fd_sc_mcu9t5v0__nor2_1
* cell instance gf180mcu_fd_sc_mcu9t5v0__nor2_1_21 r0 *1 0,0
Xgf180mcu_fd_sc_mcu9t5v0__nor2_1_21 tx_state[0] \_077_ VDD tx_state[0] vsubs
+ VSS \_107_ gf180mcu_fd_sc_mcu9t5v0__nor2_1
* cell instance gf180mcu_fd_sc_mcu9t5v0__nor2_1_22 r0 *1 0,0
Xgf180mcu_fd_sc_mcu9t5v0__nor2_1_22 tx_state[0] tx_state[1] VDD \_064_ vsubs
+ VSS \_062_ gf180mcu_fd_sc_mcu9t5v0__nor2_1
* cell instance gf180mcu_fd_sc_mcu9t5v0__nor2_2_0 r0 *1 0,0
Xgf180mcu_fd_sc_mcu9t5v0__nor2_2_0 u_destuffer/_10_ u_destuffer/_13_ VDD
+ gf180mcu_fd_sc_mcu9t5v0__nor2_2_0__VNW vsubs VSS u_destuffer/_02_
+ gf180mcu_fd_sc_mcu9t5v0__nor2_2
* cell instance gf180mcu_fd_sc_mcu9t5v0__nor2_2_1 r0 *1 0,0
Xgf180mcu_fd_sc_mcu9t5v0__nor2_2_1 u_destuffer/ones_run[0] u_destuffer/_06_ VDD
+ u_sync_detector/_03_ vsubs VSS u_destuffer/_07_
+ gf180mcu_fd_sc_mcu9t5v0__nor2_2
* cell instance gf180mcu_fd_sc_mcu9t5v0__nor2_2_2 r0 *1 0,0
Xgf180mcu_fd_sc_mcu9t5v0__nor2_2_2 DataOut[7] \_102_ VDD line_state[1] vsubs
+ VSS \_106_ gf180mcu_fd_sc_mcu9t5v0__nor2_2
* cell instance gf180mcu_fd_sc_mcu9t5v0__nor2_2_3 r0 *1 0,0
Xgf180mcu_fd_sc_mcu9t5v0__nor2_2_3 u_eop_detector/_09_ u_eop_detector/_16_ VDD
+ u_eop_detector/_01_ vsubs VSS u_eop_detector/_01_
+ gf180mcu_fd_sc_mcu9t5v0__nor2_2
* cell instance gf180mcu_fd_sc_mcu9t5v0__nor2_4_0 r0 *1 0,0
Xgf180mcu_fd_sc_mcu9t5v0__nor2_4_0 raw_mode \_000_ VDD VSS vsubs VSS
+ u_stuffer/_04_ gf180mcu_fd_sc_mcu9t5v0__nor2_4
* cell instance gf180mcu_fd_sc_mcu9t5v0__nor2_4_1 r0 *1 0,0
Xgf180mcu_fd_sc_mcu9t5v0__nor2_4_1 tx_state[2] tx_state[1] VDD
+ gf180mcu_fd_sc_mcu9t5v0__nor2_4_1__VNW vsubs VSS \_069_
+ gf180mcu_fd_sc_mcu9t5v0__nor2_4
* cell instance gf180mcu_fd_sc_mcu9t5v0__nor3_1_0 r0 *1 0,0
Xgf180mcu_fd_sc_mcu9t5v0__nor3_1_0 \_056_ \_100_ \_126_ VDD \_100_ vsubs VSS
+ \_025_ gf180mcu_fd_sc_mcu9t5v0__nor3_1
* cell instance gf180mcu_fd_sc_mcu9t5v0__nor3_1_1 r0 *1 0,0
Xgf180mcu_fd_sc_mcu9t5v0__nor3_1_1 u_sync_detector/_09_ u_sync_detector/_10_
+ u_sync_detector/_14_ VDD gf180mcu_fd_sc_mcu9t5v0__nor3_1_1__VNW vsubs VSS
+ u_sync_detector/_02_ gf180mcu_fd_sc_mcu9t5v0__nor3_1
* cell instance gf180mcu_fd_sc_mcu9t5v0__nor3_1_2 r0 *1 0,0
Xgf180mcu_fd_sc_mcu9t5v0__nor3_1_2 \_004_ eop_pulse bus_reset VDD eop_pulse
+ vsubs VSS \_118_ gf180mcu_fd_sc_mcu9t5v0__nor3_1
* cell instance gf180mcu_fd_sc_mcu9t5v0__nor3_1_3 r0 *1 0,0
Xgf180mcu_fd_sc_mcu9t5v0__nor3_1_3 u_eop_detector/_09_ u_eop_detector/_24_
+ u_eop_detector/_25_ VDD gf180mcu_fd_sc_mcu9t5v0__nor3_1_3__VNW vsubs VSS
+ u_eop_detector/_05_ gf180mcu_fd_sc_mcu9t5v0__nor3_1
* cell instance gf180mcu_fd_sc_mcu9t5v0__nor3_1_4 r0 *1 0,0
Xgf180mcu_fd_sc_mcu9t5v0__nor3_1_4 nrzi_level \_052_ \_063_ VDD VSS vsubs VSS
+ txdm gf180mcu_fd_sc_mcu9t5v0__nor3_1
* cell instance gf180mcu_fd_sc_mcu9t5v0__nor3_1_5 r0 *1 0,0
Xgf180mcu_fd_sc_mcu9t5v0__nor3_1_5 \_076_ OpMode[0] \_077_ VDD \_077_ vsubs VSS
+ \_001_ gf180mcu_fd_sc_mcu9t5v0__nor3_1
* cell instance gf180mcu_fd_sc_mcu9t5v0__nor3_1_6 r0 *1 0,0
Xgf180mcu_fd_sc_mcu9t5v0__nor3_1_6 u_eop_detector/_09_ u_eop_detector/_19_
+ u_eop_detector/_21_ VDD VSS vsubs VSS u_eop_detector/_03_
+ gf180mcu_fd_sc_mcu9t5v0__nor3_1
* cell instance gf180mcu_fd_sc_mcu9t5v0__nor3_1_7 r0 *1 0,0
Xgf180mcu_fd_sc_mcu9t5v0__nor3_1_7 u_eop_detector/se0_count[5]
+ u_eop_detector/_11_ u_eop_detector/se0_count[1] VDD VDD vsubs VSS
+ u_eop_detector/_12_ gf180mcu_fd_sc_mcu9t5v0__nor3_1
* cell instance gf180mcu_fd_sc_mcu9t5v0__nor3_1_8 r0 *1 0,0
Xgf180mcu_fd_sc_mcu9t5v0__nor3_1_8 u_stuffer/run[1] u_stuffer/_03_
+ u_stuffer/_05_ VDD gf180mcu_fd_sc_mcu9t5v0__nor3_1_8__VNW vsubs VSS
+ stuff_pending_after gf180mcu_fd_sc_mcu9t5v0__nor3_1
* cell instance gf180mcu_fd_sc_mcu9t5v0__nor3_1_9 r0 *1 0,0
Xgf180mcu_fd_sc_mcu9t5v0__nor3_1_9 \_089_ \_082_ \_090_ VDD byte_idx[2] vsubs
+ VSS \_000_ gf180mcu_fd_sc_mcu9t5v0__nor3_1
* cell instance gf180mcu_fd_sc_mcu9t5v0__nor3_1_10 r0 *1 0,0
Xgf180mcu_fd_sc_mcu9t5v0__nor3_1_10 tx_state[2] \_062_ \_094_ VDD \_062_ vsubs
+ VSS \_095_ gf180mcu_fd_sc_mcu9t5v0__nor3_1
* cell instance gf180mcu_fd_sc_mcu9t5v0__nor3_2_0 r0 *1 0,0
Xgf180mcu_fd_sc_mcu9t5v0__nor3_2_0 u_sync_detector/_09_ u_sync_detector/_11_
+ u_sync_detector/_12_ VDD VSS vsubs VSS u_sync_detector/_01_
+ gf180mcu_fd_sc_mcu9t5v0__nor3_2
* cell instance gf180mcu_fd_sc_mcu9t5v0__nor3_2_1 r0 *1 0,0
Xgf180mcu_fd_sc_mcu9t5v0__nor3_2_1 u_sync_detector/_08_ u_sync_detector/_09_
+ u_sync_detector/_11_ VDD u_sync_detector/_11_ vsubs VSS u_sync_detector/_00_
+ gf180mcu_fd_sc_mcu9t5v0__nor3_2
* cell instance gf180mcu_fd_sc_mcu9t5v0__nor3_4_0 r0 *1 0,0
Xgf180mcu_fd_sc_mcu9t5v0__nor3_4_0 \_001_ nrzi_level \_007_ VDD TxValid vsubs
+ VSS u_encoder/_1_ gf180mcu_fd_sc_mcu9t5v0__nor3_4
* cell instance gf180mcu_fd_sc_mcu9t5v0__nor3_4_1 r0 *1 0,0
Xgf180mcu_fd_sc_mcu9t5v0__nor3_4_1 tx_state[2] tx_state[0] tx_state[1] VDD
+ byte_idx[2] vsubs VSS \_052_ gf180mcu_fd_sc_mcu9t5v0__nor3_4
* cell instance gf180mcu_fd_sc_mcu9t5v0__nor4_1_0 r0 *1 0,0
Xgf180mcu_fd_sc_mcu9t5v0__nor4_1_0 u_eop_detector/se0_count[3]
+ u_eop_detector/se0_count[4] u_eop_detector/se0_count[2] u_eop_detector/_09_
+ VDD VSS vsubs VSS u_eop_detector/_26_ gf180mcu_fd_sc_mcu9t5v0__nor4_1
* cell instance gf180mcu_fd_sc_mcu9t5v0__nor4_1_1 r0 *1 0,0
Xgf180mcu_fd_sc_mcu9t5v0__nor4_1_1 tx_state[2] tx_state[0] \_065_ \_139_ VDD
+ tx_state[0] vsubs VSS \_140_ gf180mcu_fd_sc_mcu9t5v0__nor4_1
* cell instance gf180mcu_fd_sc_mcu9t5v0__nor4_2_0 r0 *1 0,0
Xgf180mcu_fd_sc_mcu9t5v0__nor4_2_0 tx_state[2] tx_state[0] \_065_ stuff_consume
+ VDD \_006_ vsubs VSS \_092_ gf180mcu_fd_sc_mcu9t5v0__nor4_2
* cell instance gf180mcu_fd_sc_mcu9t5v0__nor4_4_0 r0 *1 0,0
Xgf180mcu_fd_sc_mcu9t5v0__nor4_4_0 u_sync_detector/match[3]
+ u_sync_detector/_05_ u_sync_detector/_06_ u_sync_detector/_07_ VDD
+ clknet_3_3__leaf_clk vsubs VSS sync_next gf180mcu_fd_sc_mcu9t5v0__nor4_4
* cell instance gf180mcu_fd_sc_mcu9t5v0__nor4_4_1 r0 *1 0,0
Xgf180mcu_fd_sc_mcu9t5v0__nor4_4_1 u_eop_detector/se0_count[5]
+ u_eop_detector/_11_ u_eop_detector/_14_ u_eop_detector/_10_ VDD VDD vsubs VSS
+ u_eop_detector/_15_ gf180mcu_fd_sc_mcu9t5v0__nor4_4
* cell instance gf180mcu_fd_sc_mcu9t5v0__nor4_4_2 r0 *1 0,0
Xgf180mcu_fd_sc_mcu9t5v0__nor4_4_2 tx_state[2] tx_state[0] \_065_ \_066_ VDD
+ gf180mcu_fd_sc_mcu9t5v0__nor4_4_2__VNW vsubs VSS \_067_
+ gf180mcu_fd_sc_mcu9t5v0__nor4_4
* cell instance gf180mcu_fd_sc_mcu9t5v0__oai211_1_0 r0 *1 0,0
Xgf180mcu_fd_sc_mcu9t5v0__oai211_1_0 \_072_ \_073_ \_074_ \_055_ VDD
+ gf180mcu_fd_sc_mcu9t5v0__oai211_1_0__VNW vsubs VSS \_011_
+ gf180mcu_fd_sc_mcu9t5v0__oai211_1
* cell instance gf180mcu_fd_sc_mcu9t5v0__oai211_1_1 r0 *1 0,0
Xgf180mcu_fd_sc_mcu9t5v0__oai211_1_1 tx_state[2] \_062_ \_055_ \_075_ VDD
+ \_055_ vsubs VSS \_006_ gf180mcu_fd_sc_mcu9t5v0__oai211_1
* cell instance gf180mcu_fd_sc_mcu9t5v0__oai211_1_2 r0 *1 0,0
Xgf180mcu_fd_sc_mcu9t5v0__oai211_1_2 \_084_ \_077_ \_087_ \_055_ VDD \_086_
+ vsubs VSS \_088_ gf180mcu_fd_sc_mcu9t5v0__oai211_1
* cell instance gf180mcu_fd_sc_mcu9t5v0__oai211_1_3 r0 *1 0,0
Xgf180mcu_fd_sc_mcu9t5v0__oai211_1_3 \_085_ \_080_ \_086_ byte_idx[0] VDD
+ \_086_ vsubs VSS \_087_ gf180mcu_fd_sc_mcu9t5v0__oai211_1
* cell instance gf180mcu_fd_sc_mcu9t5v0__oai211_1_4 r0 *1 0,0
Xgf180mcu_fd_sc_mcu9t5v0__oai211_1_4 \_131_ \_132_ \_075_ \_055_ VDD \_075_
+ vsubs VSS \_133_ gf180mcu_fd_sc_mcu9t5v0__oai211_1
* cell instance gf180mcu_fd_sc_mcu9t5v0__oai211_1_5 r0 *1 0,0
Xgf180mcu_fd_sc_mcu9t5v0__oai211_1_5 tx_state[0] \_139_ tx_state[1] \_060_ VDD
+ gf180mcu_fd_sc_mcu9t5v0__oai211_1_5__VNW vsubs VSS \_143_
+ gf180mcu_fd_sc_mcu9t5v0__oai211_1
* cell instance gf180mcu_fd_sc_mcu9t5v0__oai21_1_0 r0 *1 0,0
Xgf180mcu_fd_sc_mcu9t5v0__oai21_1_0 rx_bitcnt[2] \_100_ \_002_ VDD rx_bitcnt[2]
+ vsubs VSS \_148_ gf180mcu_fd_sc_mcu9t5v0__oai21_1
* cell instance gf180mcu_fd_sc_mcu9t5v0__oai21_1_1 r0 *1 0,0
Xgf180mcu_fd_sc_mcu9t5v0__oai21_1_1 rx_bitcnt[0] \_099_ \_002_ VDD
+ gf180mcu_fd_sc_mcu9t5v0__oai21_1_1__VNW vsubs VSS \_127_
+ gf180mcu_fd_sc_mcu9t5v0__oai21_1
* cell instance gf180mcu_fd_sc_mcu9t5v0__oai21_1_2 r0 *1 0,0
Xgf180mcu_fd_sc_mcu9t5v0__oai21_1_2 line_state[1] \_058_ \_055_ VDD
+ line_state[1] vsubs VSS \_009_ gf180mcu_fd_sc_mcu9t5v0__oai21_1
* cell instance gf180mcu_fd_sc_mcu9t5v0__oai21_1_3 r0 *1 0,0
Xgf180mcu_fd_sc_mcu9t5v0__oai21_1_3 \_138_ \_144_ \_145_ VDD VSS vsubs VSS
+ \_032_ gf180mcu_fd_sc_mcu9t5v0__oai21_1
* cell instance gf180mcu_fd_sc_mcu9t5v0__oai221_4_0 r0 *1 0,0
Xgf180mcu_fd_sc_mcu9t5v0__oai221_4_0 stuff_consume \_089_ \_067_ \_052_ TxValid
+ VDD VSS vsubs VSS \_102_ gf180mcu_fd_sc_mcu9t5v0__oai221_4
* cell instance gf180mcu_fd_sc_mcu9t5v0__oai22_1_0 r0 *1 0,0
Xgf180mcu_fd_sc_mcu9t5v0__oai22_1_0 u_stuffer/_03_ \_005_ u_stuffer/_06_
+ u_stuffer/_08_ VDD VSS vsubs VSS u_stuffer/_00_
+ gf180mcu_fd_sc_mcu9t5v0__oai22_1
* cell instance gf180mcu_fd_sc_mcu9t5v0__oai22_1_1 r0 *1 0,0
Xgf180mcu_fd_sc_mcu9t5v0__oai22_1_1 \_161_ \_133_ \_145_ \_131_ VDD \_133_
+ vsubs VSS \_050_ gf180mcu_fd_sc_mcu9t5v0__oai22_1
* cell instance gf180mcu_fd_sc_mcu9t5v0__or2_1_0 r0 *1 0,0
Xgf180mcu_fd_sc_mcu9t5v0__or2_1_0 \_009_ \_059_ VDD \$464 vsubs VSS \_008_
+ gf180mcu_fd_sc_mcu9t5v0__or2_1
* cell instance gf180mcu_fd_sc_mcu9t5v0__or2_1_1 r0 *1 0,0
Xgf180mcu_fd_sc_mcu9t5v0__or2_1_1 byte_idx[0] byte_idx[1] VDD \$275 vsubs VSS
+ \_082_ gf180mcu_fd_sc_mcu9t5v0__or2_1
* cell instance gf180mcu_fd_sc_mcu9t5v0__or2_1_2 r0 *1 0,0
Xgf180mcu_fd_sc_mcu9t5v0__or2_1_2 \_070_ \_089_ VDD \$436 vsubs VSS \_136_
+ gf180mcu_fd_sc_mcu9t5v0__or2_1
* cell instance gf180mcu_fd_sc_mcu9t5v0__xnor2_1_0 r0 *1 0,0
Xgf180mcu_fd_sc_mcu9t5v0__xnor2_1_0 u_destuffer/ones_run[1] u_destuffer/_12_
+ VDD gf180mcu_fd_sc_mcu9t5v0__xnor2_1_0__VNW vsubs VSS u_destuffer/_13_
+ gf180mcu_fd_sc_mcu9t5v0__xnor2_1
* cell instance gf180mcu_fd_sc_mcu9t5v0__xnor2_1_1 r0 *1 0,0
Xgf180mcu_fd_sc_mcu9t5v0__xnor2_1_1 \_009_ u_decoder/prev_level VDD \_009_
+ vsubs VSS u_decoder/_03_ gf180mcu_fd_sc_mcu9t5v0__xnor2_1
* cell instance gf180mcu_fd_sc_mcu9t5v0__xnor2_1_2 r0 *1 0,0
Xgf180mcu_fd_sc_mcu9t5v0__xnor2_1_2 u_eop_detector/se0_count[2]
+ u_eop_detector/_15_ VDD gf180mcu_fd_sc_mcu9t5v0__xnor2_1_2__VNW vsubs VSS
+ u_eop_detector/_16_ gf180mcu_fd_sc_mcu9t5v0__xnor2_1
* cell instance gf180mcu_fd_sc_mcu9t5v0__xnor2_4_0 r0 *1 0,0
Xgf180mcu_fd_sc_mcu9t5v0__xnor2_4_0 sync_idx[0] \_091_ VDD
+ gf180mcu_fd_sc_mcu9t5v0__xnor2_4_0__VNW vsubs VSS \_134_
+ gf180mcu_fd_sc_mcu9t5v0__xnor2_4
* cell instance gf180mcu_fd_sc_mcu9t5v0__xor2_1_0 r0 *1 0,0
Xgf180mcu_fd_sc_mcu9t5v0__xor2_1_0 u_stuffer/run[1] u_stuffer/_10_ VDD
+ u_stuffer/_10_ vsubs VSS u_stuffer/_11_ gf180mcu_fd_sc_mcu9t5v0__xor2_1
* cell instance gf180mcu_fd_sc_mcu9t5v0__xor2_2_0 r0 *1 0,0
Xgf180mcu_fd_sc_mcu9t5v0__xor2_2_0 \_011_ u_encoder/_1_ VDD
+ gf180mcu_fd_sc_mcu9t5v0__xor2_2_0__VNW vsubs VSS u_encoder/_2_
+ gf180mcu_fd_sc_mcu9t5v0__xor2_2
* cell instance gf180mcu_fd_sc_mcu9t5v0__xor2_2_1 r0 *1 0,0
Xgf180mcu_fd_sc_mcu9t5v0__xor2_2_1 u_stuffer/run[2] u_stuffer/_12_ VDD VDD
+ vsubs VSS u_stuffer/_13_ gf180mcu_fd_sc_mcu9t5v0__xor2_2
.ENDS usb_utmi_phy

* cell gf180mcu_fd_sc_mcu9t5v0__xor2_2
* pin A1
* pin A2
* pin VDD
* pin VNW
* pin VPW
* pin VSS
* pin Z
.SUBCKT gf180mcu_fd_sc_mcu9t5v0__xor2_2 A1 A2 VDD VNW VPW VSS Z
.ENDS gf180mcu_fd_sc_mcu9t5v0__xor2_2

* cell gf180mcu_fd_sc_mcu9t5v0__xor2_1
* pin A1
* pin A2
* pin VDD
* pin VNW
* pin VPW
* pin VSS
* pin Z
.SUBCKT gf180mcu_fd_sc_mcu9t5v0__xor2_1 A1 A2 VDD VNW VPW VSS Z
.ENDS gf180mcu_fd_sc_mcu9t5v0__xor2_1

* cell gf180mcu_fd_sc_mcu9t5v0__xnor2_4
* pin A1
* pin A2
* pin VDD
* pin VNW
* pin VPW
* pin VSS
* pin ZN
.SUBCKT gf180mcu_fd_sc_mcu9t5v0__xnor2_4 A1 A2 VDD VNW VPW VSS ZN
.ENDS gf180mcu_fd_sc_mcu9t5v0__xnor2_4

* cell gf180mcu_fd_sc_mcu9t5v0__xnor2_1
* pin A1
* pin A2
* pin VDD
* pin VNW
* pin VPW
* pin VSS
* pin ZN
.SUBCKT gf180mcu_fd_sc_mcu9t5v0__xnor2_1 A1 A2 VDD VNW VPW VSS ZN
.ENDS gf180mcu_fd_sc_mcu9t5v0__xnor2_1

* cell gf180mcu_fd_sc_mcu9t5v0__or2_1
* pin A1
* pin A2
* pin VDD
* pin VNW
* pin VPW
* pin VSS
* pin Z
.SUBCKT gf180mcu_fd_sc_mcu9t5v0__or2_1 A1 A2 VDD VNW VPW VSS Z
.ENDS gf180mcu_fd_sc_mcu9t5v0__or2_1

* cell gf180mcu_fd_sc_mcu9t5v0__oai22_1
* pin A1
* pin A2
* pin B1
* pin B2
* pin VDD
* pin VNW
* pin VPW
* pin VSS
* pin ZN
.SUBCKT gf180mcu_fd_sc_mcu9t5v0__oai22_1 A1 A2 B1 B2 VDD VNW VPW VSS ZN
.ENDS gf180mcu_fd_sc_mcu9t5v0__oai22_1

* cell gf180mcu_fd_sc_mcu9t5v0__oai221_4
* pin A1
* pin A2
* pin B1
* pin B2
* pin C
* pin VDD
* pin VNW
* pin VPW
* pin VSS
* pin ZN
.SUBCKT gf180mcu_fd_sc_mcu9t5v0__oai221_4 A1 A2 B1 B2 C VDD VNW VPW VSS ZN
.ENDS gf180mcu_fd_sc_mcu9t5v0__oai221_4

* cell gf180mcu_fd_sc_mcu9t5v0__oai21_1
* pin A1
* pin A2
* pin B
* pin VDD
* pin VNW
* pin VPW
* pin VSS
* pin ZN
.SUBCKT gf180mcu_fd_sc_mcu9t5v0__oai21_1 A1 A2 B VDD VNW VPW VSS ZN
.ENDS gf180mcu_fd_sc_mcu9t5v0__oai21_1

* cell gf180mcu_fd_sc_mcu9t5v0__oai211_1
* pin A1
* pin A2
* pin B
* pin C
* pin VDD
* pin VNW
* pin VPW
* pin VSS
* pin ZN
.SUBCKT gf180mcu_fd_sc_mcu9t5v0__oai211_1 A1 A2 B C VDD VNW VPW VSS ZN
.ENDS gf180mcu_fd_sc_mcu9t5v0__oai211_1

* cell gf180mcu_fd_sc_mcu9t5v0__nor4_4
* pin A1
* pin A2
* pin A3
* pin A4
* pin VDD
* pin VNW
* pin VPW
* pin VSS
* pin ZN
.SUBCKT gf180mcu_fd_sc_mcu9t5v0__nor4_4 A1 A2 A3 A4 VDD VNW VPW VSS ZN
.ENDS gf180mcu_fd_sc_mcu9t5v0__nor4_4

* cell gf180mcu_fd_sc_mcu9t5v0__nor4_2
* pin A1
* pin A2
* pin A3
* pin A4
* pin VDD
* pin VNW
* pin VPW
* pin VSS
* pin ZN
.SUBCKT gf180mcu_fd_sc_mcu9t5v0__nor4_2 A1 A2 A3 A4 VDD VNW VPW VSS ZN
.ENDS gf180mcu_fd_sc_mcu9t5v0__nor4_2

* cell gf180mcu_fd_sc_mcu9t5v0__nor4_1
* pin A1
* pin A2
* pin A3
* pin A4
* pin VDD
* pin VNW
* pin VPW
* pin VSS
* pin ZN
.SUBCKT gf180mcu_fd_sc_mcu9t5v0__nor4_1 A1 A2 A3 A4 VDD VNW VPW VSS ZN
.ENDS gf180mcu_fd_sc_mcu9t5v0__nor4_1

* cell gf180mcu_fd_sc_mcu9t5v0__nor3_4
* pin A1
* pin A2
* pin A3
* pin VDD
* pin VNW
* pin VPW
* pin VSS
* pin ZN
.SUBCKT gf180mcu_fd_sc_mcu9t5v0__nor3_4 A1 A2 A3 VDD VNW VPW VSS ZN
.ENDS gf180mcu_fd_sc_mcu9t5v0__nor3_4

* cell gf180mcu_fd_sc_mcu9t5v0__nor3_2
* pin A1
* pin A2
* pin A3
* pin VDD
* pin VNW
* pin VPW
* pin VSS
* pin ZN
.SUBCKT gf180mcu_fd_sc_mcu9t5v0__nor3_2 A1 A2 A3 VDD VNW VPW VSS ZN
.ENDS gf180mcu_fd_sc_mcu9t5v0__nor3_2

* cell gf180mcu_fd_sc_mcu9t5v0__nor3_1
* pin A1
* pin A2
* pin A3
* pin VDD
* pin VNW
* pin VPW
* pin VSS
* pin ZN
.SUBCKT gf180mcu_fd_sc_mcu9t5v0__nor3_1 A1 A2 A3 VDD VNW VPW VSS ZN
.ENDS gf180mcu_fd_sc_mcu9t5v0__nor3_1

* cell gf180mcu_fd_sc_mcu9t5v0__nor2_4
* pin A1
* pin A2
* pin VDD
* pin VNW
* pin VPW
* pin VSS
* pin ZN
.SUBCKT gf180mcu_fd_sc_mcu9t5v0__nor2_4 A1 A2 VDD VNW VPW VSS ZN
.ENDS gf180mcu_fd_sc_mcu9t5v0__nor2_4

* cell gf180mcu_fd_sc_mcu9t5v0__nor2_2
* pin A1
* pin A2
* pin VDD
* pin VNW
* pin VPW
* pin VSS
* pin ZN
.SUBCKT gf180mcu_fd_sc_mcu9t5v0__nor2_2 A1 A2 VDD VNW VPW VSS ZN
.ENDS gf180mcu_fd_sc_mcu9t5v0__nor2_2

* cell gf180mcu_fd_sc_mcu9t5v0__nor2_1
* pin A1
* pin A2
* pin VDD
* pin VNW
* pin VPW
* pin VSS
* pin ZN
.SUBCKT gf180mcu_fd_sc_mcu9t5v0__nor2_1 A1 A2 VDD VNW VPW VSS ZN
.ENDS gf180mcu_fd_sc_mcu9t5v0__nor2_1

* cell gf180mcu_fd_sc_mcu9t5v0__nand4_4
* pin A1
* pin A2
* pin A3
* pin A4
* pin VDD
* pin VNW
* pin VPW
* pin VSS
* pin ZN
.SUBCKT gf180mcu_fd_sc_mcu9t5v0__nand4_4 A1 A2 A3 A4 VDD VNW VPW VSS ZN
.ENDS gf180mcu_fd_sc_mcu9t5v0__nand4_4

* cell gf180mcu_fd_sc_mcu9t5v0__nand4_1
* pin A1
* pin A2
* pin A3
* pin A4
* pin VDD
* pin VNW
* pin VPW
* pin VSS
* pin ZN
.SUBCKT gf180mcu_fd_sc_mcu9t5v0__nand4_1 A1 A2 A3 A4 VDD VNW VPW VSS ZN
.ENDS gf180mcu_fd_sc_mcu9t5v0__nand4_1

* cell gf180mcu_fd_sc_mcu9t5v0__nand3_4
* pin A1
* pin A2
* pin A3
* pin VDD
* pin VNW
* pin VPW
* pin VSS
* pin ZN
.SUBCKT gf180mcu_fd_sc_mcu9t5v0__nand3_4 A1 A2 A3 VDD VNW VPW VSS ZN
.ENDS gf180mcu_fd_sc_mcu9t5v0__nand3_4

* cell gf180mcu_fd_sc_mcu9t5v0__nand3_2
* pin A1
* pin A2
* pin A3
* pin VDD
* pin VNW
* pin VPW
* pin VSS
* pin ZN
.SUBCKT gf180mcu_fd_sc_mcu9t5v0__nand3_2 A1 A2 A3 VDD VNW VPW VSS ZN
.ENDS gf180mcu_fd_sc_mcu9t5v0__nand3_2

* cell gf180mcu_fd_sc_mcu9t5v0__nand3_1
* pin A1
* pin A2
* pin A3
* pin VDD
* pin VNW
* pin VPW
* pin VSS
* pin ZN
.SUBCKT gf180mcu_fd_sc_mcu9t5v0__nand3_1 A1 A2 A3 VDD VNW VPW VSS ZN
.ENDS gf180mcu_fd_sc_mcu9t5v0__nand3_1

* cell gf180mcu_fd_sc_mcu9t5v0__nand2_4
* pin A1
* pin A2
* pin VDD
* pin VNW
* pin VPW
* pin VSS
* pin ZN
.SUBCKT gf180mcu_fd_sc_mcu9t5v0__nand2_4 A1 A2 VDD VNW VPW VSS ZN
.ENDS gf180mcu_fd_sc_mcu9t5v0__nand2_4

* cell gf180mcu_fd_sc_mcu9t5v0__nand2_2
* pin A1
* pin A2
* pin VDD
* pin VNW
* pin VPW
* pin VSS
* pin ZN
.SUBCKT gf180mcu_fd_sc_mcu9t5v0__nand2_2 A1 A2 VDD VNW VPW VSS ZN
.ENDS gf180mcu_fd_sc_mcu9t5v0__nand2_2

* cell gf180mcu_fd_sc_mcu9t5v0__nand2_1
* pin A1
* pin A2
* pin VDD
* pin VNW
* pin VPW
* pin VSS
* pin ZN
.SUBCKT gf180mcu_fd_sc_mcu9t5v0__nand2_1 A1 A2 VDD VNW VPW VSS ZN
.ENDS gf180mcu_fd_sc_mcu9t5v0__nand2_1

* cell gf180mcu_fd_sc_mcu9t5v0__mux4_1
* pin I0
* pin I1
* pin I2
* pin I3
* pin S0
* pin S1
* pin VDD
* pin VNW
* pin VPW
* pin VSS
* pin Z
.SUBCKT gf180mcu_fd_sc_mcu9t5v0__mux4_1 I0 I1 I2 I3 S0 S1 VDD VNW VPW VSS Z
.ENDS gf180mcu_fd_sc_mcu9t5v0__mux4_1

* cell gf180mcu_fd_sc_mcu9t5v0__mux2_2
* pin I0
* pin I1
* pin S
* pin VDD
* pin VNW
* pin VPW
* pin VSS
* pin Z
.SUBCKT gf180mcu_fd_sc_mcu9t5v0__mux2_2 I0 I1 S VDD VNW VPW VSS Z
.ENDS gf180mcu_fd_sc_mcu9t5v0__mux2_2

* cell gf180mcu_fd_sc_mcu9t5v0__mux2_1
* pin I0
* pin I1
* pin S
* pin VDD
* pin VNW
* pin VPW
* pin VSS
* pin Z
.SUBCKT gf180mcu_fd_sc_mcu9t5v0__mux2_1 I0 I1 S VDD VNW VPW VSS Z
.ENDS gf180mcu_fd_sc_mcu9t5v0__mux2_1

* cell gf180mcu_fd_sc_mcu9t5v0__inv_8
* pin I
* pin VDD
* pin VNW
* pin VPW
* pin VSS
* pin ZN
.SUBCKT gf180mcu_fd_sc_mcu9t5v0__inv_8 I VDD VNW VPW VSS ZN
.ENDS gf180mcu_fd_sc_mcu9t5v0__inv_8

* cell gf180mcu_fd_sc_mcu9t5v0__inv_4
* pin I
* pin VDD
* pin VNW
* pin VPW
* pin VSS
* pin ZN
.SUBCKT gf180mcu_fd_sc_mcu9t5v0__inv_4 I VDD VNW VPW VSS ZN
.ENDS gf180mcu_fd_sc_mcu9t5v0__inv_4

* cell gf180mcu_fd_sc_mcu9t5v0__inv_3
* pin I
* pin VDD
* pin VNW
* pin VPW
* pin VSS
* pin ZN
.SUBCKT gf180mcu_fd_sc_mcu9t5v0__inv_3 I VDD VNW VPW VSS ZN
.ENDS gf180mcu_fd_sc_mcu9t5v0__inv_3

* cell gf180mcu_fd_sc_mcu9t5v0__inv_2
* pin I
* pin VDD
* pin VNW
* pin VPW
* pin VSS
* pin ZN
.SUBCKT gf180mcu_fd_sc_mcu9t5v0__inv_2 I VDD VNW VPW VSS ZN
.ENDS gf180mcu_fd_sc_mcu9t5v0__inv_2

* cell gf180mcu_fd_sc_mcu9t5v0__inv_1
* pin I
* pin VDD
* pin VNW
* pin VPW
* pin VSS
* pin ZN
.SUBCKT gf180mcu_fd_sc_mcu9t5v0__inv_1 I VDD VNW VPW VSS ZN
.ENDS gf180mcu_fd_sc_mcu9t5v0__inv_1

* cell gf180mcu_fd_sc_mcu9t5v0__filltie
* pin VDD
* pin VSS
.SUBCKT gf180mcu_fd_sc_mcu9t5v0__filltie VDD VSS
.ENDS gf180mcu_fd_sc_mcu9t5v0__filltie

* cell gf180mcu_fd_sc_mcu9t5v0__fill_8
* pin VDD
* pin VNW
* pin VPW
* pin VSS
.SUBCKT gf180mcu_fd_sc_mcu9t5v0__fill_8 VDD VNW VPW VSS
.ENDS gf180mcu_fd_sc_mcu9t5v0__fill_8

* cell gf180mcu_fd_sc_mcu9t5v0__fill_64
* pin VDD
* pin VNW
* pin VPW
* pin VSS
.SUBCKT gf180mcu_fd_sc_mcu9t5v0__fill_64 VDD VNW VPW VSS
.ENDS gf180mcu_fd_sc_mcu9t5v0__fill_64

* cell gf180mcu_fd_sc_mcu9t5v0__fill_4
* pin VDD
* pin VNW
* pin VPW
* pin VSS
.SUBCKT gf180mcu_fd_sc_mcu9t5v0__fill_4 VDD VNW VPW VSS
.ENDS gf180mcu_fd_sc_mcu9t5v0__fill_4

* cell gf180mcu_fd_sc_mcu9t5v0__fill_32
* pin VDD
* pin VNW
* pin VPW
* pin VSS
.SUBCKT gf180mcu_fd_sc_mcu9t5v0__fill_32 VDD VNW VPW VSS
.ENDS gf180mcu_fd_sc_mcu9t5v0__fill_32

* cell gf180mcu_fd_sc_mcu9t5v0__fill_2
* pin VDD
* pin VNW
* pin VPW
* pin VSS
.SUBCKT gf180mcu_fd_sc_mcu9t5v0__fill_2 VDD VNW VPW VSS
.ENDS gf180mcu_fd_sc_mcu9t5v0__fill_2

* cell gf180mcu_fd_sc_mcu9t5v0__fill_16
* pin VDD
* pin VNW
* pin VPW
* pin VSS
.SUBCKT gf180mcu_fd_sc_mcu9t5v0__fill_16 VDD VNW VPW VSS
.ENDS gf180mcu_fd_sc_mcu9t5v0__fill_16

* cell gf180mcu_fd_sc_mcu9t5v0__fill_1
* pin VDD
* pin VNW
* pin VPW
* pin VSS
.SUBCKT gf180mcu_fd_sc_mcu9t5v0__fill_1 VDD VNW VPW VSS
.ENDS gf180mcu_fd_sc_mcu9t5v0__fill_1

* cell gf180mcu_fd_sc_mcu9t5v0__endcap
* pin VDD
* pin VSS
.SUBCKT gf180mcu_fd_sc_mcu9t5v0__endcap VDD VSS
.ENDS gf180mcu_fd_sc_mcu9t5v0__endcap

* cell gf180mcu_fd_sc_mcu9t5v0__dffsnq_1
* pin CLK
* pin D
* pin Q
* pin SETN
* pin VDD
* pin VNW
* pin VPW
* pin VSS
.SUBCKT gf180mcu_fd_sc_mcu9t5v0__dffsnq_1 CLK D Q SETN VDD VNW VPW VSS
.ENDS gf180mcu_fd_sc_mcu9t5v0__dffsnq_1

* cell gf180mcu_fd_sc_mcu9t5v0__dffrnq_1
* pin CLK
* pin D
* pin Q
* pin RN
* pin VDD
* pin VNW
* pin VPW
* pin VSS
.SUBCKT gf180mcu_fd_sc_mcu9t5v0__dffrnq_1 CLK D Q RN VDD VNW VPW VSS
.ENDS gf180mcu_fd_sc_mcu9t5v0__dffrnq_1

* cell gf180mcu_fd_sc_mcu9t5v0__dffq_1
* pin CLK
* pin D
* pin Q
* pin VDD
* pin VNW
* pin VPW
* pin VSS
.SUBCKT gf180mcu_fd_sc_mcu9t5v0__dffq_1 CLK D Q VDD VNW VPW VSS
.ENDS gf180mcu_fd_sc_mcu9t5v0__dffq_1

* cell gf180mcu_fd_sc_mcu9t5v0__clkinv_8
* pin I
* pin VDD
* pin VNW
* pin VPW
* pin VSS
* pin ZN
.SUBCKT gf180mcu_fd_sc_mcu9t5v0__clkinv_8 I VDD VNW VPW VSS ZN
.ENDS gf180mcu_fd_sc_mcu9t5v0__clkinv_8

* cell gf180mcu_fd_sc_mcu9t5v0__clkinv_2
* pin I
* pin VDD
* pin VNW
* pin VPW
* pin VSS
* pin ZN
.SUBCKT gf180mcu_fd_sc_mcu9t5v0__clkinv_2 I VDD VNW VPW VSS ZN
.ENDS gf180mcu_fd_sc_mcu9t5v0__clkinv_2

* cell gf180mcu_fd_sc_mcu9t5v0__clkinv_1
* pin I
* pin VDD
* pin VNW
* pin VPW
* pin VSS
* pin ZN
.SUBCKT gf180mcu_fd_sc_mcu9t5v0__clkinv_1 I VDD VNW VPW VSS ZN
.ENDS gf180mcu_fd_sc_mcu9t5v0__clkinv_1

* cell gf180mcu_fd_sc_mcu9t5v0__buf_4
* pin I
* pin VDD
* pin VNW
* pin VPW
* pin VSS
* pin Z
.SUBCKT gf180mcu_fd_sc_mcu9t5v0__buf_4 I VDD VNW VPW VSS Z
.ENDS gf180mcu_fd_sc_mcu9t5v0__buf_4

* cell gf180mcu_fd_sc_mcu9t5v0__aoi221_2
* pin A1
* pin A2
* pin B1
* pin B2
* pin C
* pin VDD
* pin VNW
* pin VPW
* pin VSS
* pin ZN
.SUBCKT gf180mcu_fd_sc_mcu9t5v0__aoi221_2 A1 A2 B1 B2 C VDD VNW VPW VSS ZN
.ENDS gf180mcu_fd_sc_mcu9t5v0__aoi221_2

* cell gf180mcu_fd_sc_mcu9t5v0__aoi221_1
* pin A1
* pin A2
* pin B1
* pin B2
* pin C
* pin VDD
* pin VNW
* pin VPW
* pin VSS
* pin ZN
.SUBCKT gf180mcu_fd_sc_mcu9t5v0__aoi221_1 A1 A2 B1 B2 C VDD VNW VPW VSS ZN
.ENDS gf180mcu_fd_sc_mcu9t5v0__aoi221_1

* cell gf180mcu_fd_sc_mcu9t5v0__aoi21_4
* pin A1
* pin A2
* pin B
* pin VDD
* pin VNW
* pin VPW
* pin VSS
* pin ZN
.SUBCKT gf180mcu_fd_sc_mcu9t5v0__aoi21_4 A1 A2 B VDD VNW VPW VSS ZN
.ENDS gf180mcu_fd_sc_mcu9t5v0__aoi21_4

* cell gf180mcu_fd_sc_mcu9t5v0__aoi21_2
* pin A1
* pin A2
* pin B
* pin VDD
* pin VNW
* pin VPW
* pin VSS
* pin ZN
.SUBCKT gf180mcu_fd_sc_mcu9t5v0__aoi21_2 A1 A2 B VDD VNW VPW VSS ZN
.ENDS gf180mcu_fd_sc_mcu9t5v0__aoi21_2

* cell gf180mcu_fd_sc_mcu9t5v0__aoi21_1
* pin A1
* pin A2
* pin B
* pin VDD
* pin VNW
* pin VPW
* pin VSS
* pin ZN
.SUBCKT gf180mcu_fd_sc_mcu9t5v0__aoi21_1 A1 A2 B VDD VNW VPW VSS ZN
.ENDS gf180mcu_fd_sc_mcu9t5v0__aoi21_1

* cell gf180mcu_fd_sc_mcu9t5v0__aoi211_2
* pin A1
* pin A2
* pin B
* pin C
* pin VDD
* pin VNW
* pin VPW
* pin VSS
* pin ZN
.SUBCKT gf180mcu_fd_sc_mcu9t5v0__aoi211_2 A1 A2 B C VDD VNW VPW VSS ZN
.ENDS gf180mcu_fd_sc_mcu9t5v0__aoi211_2

* cell gf180mcu_fd_sc_mcu9t5v0__aoi211_1
* pin A1
* pin A2
* pin B
* pin C
* pin VDD
* pin VNW
* pin VPW
* pin VSS
* pin ZN
.SUBCKT gf180mcu_fd_sc_mcu9t5v0__aoi211_1 A1 A2 B C VDD VNW VPW VSS ZN
.ENDS gf180mcu_fd_sc_mcu9t5v0__aoi211_1

* cell gf180mcu_fd_sc_mcu9t5v0__and4_1
* pin A1
* pin A2
* pin A3
* pin A4
* pin VDD
* pin VNW
* pin VPW
* pin VSS
* pin Z
.SUBCKT gf180mcu_fd_sc_mcu9t5v0__and4_1 A1 A2 A3 A4 VDD VNW VPW VSS Z
.ENDS gf180mcu_fd_sc_mcu9t5v0__and4_1

* cell gf180mcu_fd_sc_mcu9t5v0__and3_4
* pin A1
* pin A2
* pin A3
* pin VDD
* pin VNW
* pin VPW
* pin VSS
* pin Z
.SUBCKT gf180mcu_fd_sc_mcu9t5v0__and3_4 A1 A2 A3 VDD VNW VPW VSS Z
.ENDS gf180mcu_fd_sc_mcu9t5v0__and3_4

* cell gf180mcu_fd_sc_mcu9t5v0__and3_2
* pin A1
* pin A2
* pin A3
* pin VDD
* pin VNW
* pin VPW
* pin VSS
* pin Z
.SUBCKT gf180mcu_fd_sc_mcu9t5v0__and3_2 A1 A2 A3 VDD VNW VPW VSS Z
.ENDS gf180mcu_fd_sc_mcu9t5v0__and3_2

* cell gf180mcu_fd_sc_mcu9t5v0__and3_1
* pin A1
* pin A2
* pin A3
* pin VDD
* pin VNW
* pin VPW
* pin VSS
* pin Z
.SUBCKT gf180mcu_fd_sc_mcu9t5v0__and3_1 A1 A2 A3 VDD VNW VPW VSS Z
.ENDS gf180mcu_fd_sc_mcu9t5v0__and3_1

* cell gf180mcu_fd_sc_mcu9t5v0__and2_4
* pin A1
* pin A2
* pin VDD
* pin VNW
* pin VPW
* pin VSS
* pin Z
.SUBCKT gf180mcu_fd_sc_mcu9t5v0__and2_4 A1 A2 VDD VNW VPW VSS Z
.ENDS gf180mcu_fd_sc_mcu9t5v0__and2_4

* cell gf180mcu_fd_sc_mcu9t5v0__and2_2
* pin A1
* pin A2
* pin VDD
* pin VNW
* pin VPW
* pin VSS
* pin Z
.SUBCKT gf180mcu_fd_sc_mcu9t5v0__and2_2 A1 A2 VDD VNW VPW VSS Z
.ENDS gf180mcu_fd_sc_mcu9t5v0__and2_2

* cell gf180mcu_fd_sc_mcu9t5v0__and2_1
* pin A1
* pin A2
* pin VDD
* pin VNW
* pin VPW
* pin VSS
* pin Z
.SUBCKT gf180mcu_fd_sc_mcu9t5v0__and2_1 A1 A2 VDD VNW VPW VSS Z
.ENDS gf180mcu_fd_sc_mcu9t5v0__and2_1
