* Frozen netlist snapshot for record 20261010-065704-8e5ea08
* source     : sim/driver-signal-quality/testbench/driver_tb.spice
* sha256     : 782b3fddae62244a3dc4a620b73e4cd147f12ed8c5b7e05eea4ed24701e1b729
* This is a verbatim copy taken at record time. Do not edit.
* driver-signal-quality -- differential driver into the ratified 50 pF test load
*
* Netlist FRAGMENT. The harness supplies the title, the .include of the
* gf180mcu models, the corner .lib sections, .temp, the .control block and
* .end. Parameters provided by the harness: vdd_val, vdd_nom, temp_c.
*
* DUT: design/netlist/differential_driver.spice (named by tb.json's "dut"),
* the schematic-level export of design/differential_driver.sch.
*
* What this substantiates (spec/usb2-device-phy.md):
*   §6  rise time 10-90 %          4-20 ns into 50 pF
*   §6  fall time 90-10 %          4-20 ns into 50 pF
*   §6  rise/fall matching         within 10 % of each other
*   §6  output crossover voltage   1.3-2.0 V
*   §8.2 full-speed signal quality  the three rows above checked as a set,
*        plus a monotonic, single-zero-crossing transition (see below)
*
* Load: 50 pF from each of D+/D- to ground, which is exactly the test-load
* condition §6 ratifies ("Test load: 50 pF, into which rise/fall times above
* are measured"). No resistive termination is added: the ratified row names a
* capacitance and nothing else, and adding an unratified resistor would change
* the numbers this record claims against.
*
* Stimulus: one J->K->J style differential transition pair. TXDP/TXDM are
* driven as a complementary CMOS pair (that is what the UTMI-side logic
* presents to this block), rising at 100 ns and falling at 200 ns, so the
* window holds exactly one full rising edge and one full falling edge with
* time to settle either side. The 100 ns half-period is slightly longer than
* the 83.33 ns full-speed bit time on purpose: settling, not bit-rate
* fidelity, is what a rise/fall measurement needs. Data-dependent edge timing
* at the real 12 Mbps bit rate is a separate experiment (driver-jitter).
*
* .csparam publishes the per-corner 10 %/90 % levels into the control block so
* the meas thresholds follow the supply the harness set for this PVT point
* rather than a frozen nominal. (.csparam is not one of the directives a
* fragment is forbidden to own -- see sim/harness/README.md.)

.csparam v10={0.1*vdd_val}
.csparam v90={0.9*vdd_val}

vsup VDD 0 dc {vdd_val}

vtxdp TXDP 0 pulse(0 {vdd_val} 100n 0.5n 0.5n 100n 200n)
vtxdm TXDM 0 pulse({vdd_val} 0 100n 0.5n 0.5n 100n 200n)

* TXOE (issue #114): driver permanently enabled for the edge-quality
* measurement, so the §6 checks apply to the enabled driver. The 10 %/90 %
* reference nodes exist for the klt batch backend, whose .meas cards cannot
* use the control-block $& substitution the local derive path uses.
vtxoe TXOE 0 dc {vdd_val}
bdpn dpn 0 v=v(dp)/v(vdd)
bdpo dpo 0 v=v(dp)-v(vdd)

Xdrv VDD 0 TXDP TXDM TXOE DP DM differential_driver

cdp DP 0 50p
cdm DM 0 50p

* ---------------------------------------------------------------
* DUT netlist included by this testbench (schematic)
* source     : design/netlist/differential_driver.spice
* sha256     : 2e3644caa25cdaaeb4daaf1aa2e34578b23b2790b142773b4b4134631e4dd9de
* ---------------------------------------------------------------

* differential_driver -- generated by design/netlist.py from design/differential_driver.sch
* Do not edit: edit the schematic and re-run the export.
** sch_path: design/differential_driver.sch
.subckt differential_driver VDD VSS TXDP TXDM TXOE DP DM
*.PININFO VDD:B VSS:B TXDP:I TXDM:I TXOE:I DP:B DM:B
XMPOEB TXOEB TXOE VDD VDD pfet_03v3 L=0.28u W=4u nf=1 ad='int((nf+1)/2) * W/nf * 0.18u' as='int((nf+2)/2) * W/nf * 0.18u' pd='2*int((nf+1)/2) * (W/nf + 0.18u)'
+ ps='2*int((nf+2)/2) * (W/nf + 0.18u)' nrd='0.18u / W' nrs='0.18u / W' sa=0 sb=0 sd=0 m=1
XMNOEB TXOEB TXOE VSS VSS nfet_03v3 L=0.28u W=2u nf=1 ad='int((nf+1)/2) * W/nf * 0.18u' as='int((nf+2)/2) * W/nf * 0.18u' pd='2*int((nf+1)/2) * (W/nf + 0.18u)'
+ ps='2*int((nf+2)/2) * (W/nf + 0.18u)' nrd='0.18u / W' nrs='0.18u / W' sa=0 sb=0 sd=0 m=1
XMP1ADP DP_PREP TXDP VDD VDD pfet_03v3 L=0.28u W=4u nf=1 ad='int((nf+1)/2) * W/nf * 0.18u' as='int((nf+2)/2) * W/nf * 0.18u' pd='2*int((nf+1)/2) * (W/nf + 0.18u)'
+ ps='2*int((nf+2)/2) * (W/nf + 0.18u)' nrd='0.18u / W' nrs='0.18u / W' sa=0 sb=0 sd=0 m=1
XMP1BDP DP_PREP TXOE VDD VDD pfet_03v3 L=0.28u W=4u nf=1 ad='int((nf+1)/2) * W/nf * 0.18u' as='int((nf+2)/2) * W/nf * 0.18u' pd='2*int((nf+1)/2) * (W/nf + 0.18u)'
+ ps='2*int((nf+2)/2) * (W/nf + 0.18u)' nrd='0.18u / W' nrs='0.18u / W' sa=0 sb=0 sd=0 m=1
XMN1ADP DP_PREP TXDP DP_NX VSS nfet_03v3 L=0.28u W=4u nf=1 ad='int((nf+1)/2) * W/nf * 0.18u' as='int((nf+2)/2) * W/nf * 0.18u' pd='2*int((nf+1)/2) * (W/nf + 0.18u)'
+ ps='2*int((nf+2)/2) * (W/nf + 0.18u)' nrd='0.18u / W' nrs='0.18u / W' sa=0 sb=0 sd=0 m=1
XMN1BDP DP_NX TXOE VSS VSS nfet_03v3 L=0.28u W=4u nf=1 ad='int((nf+1)/2) * W/nf * 0.18u' as='int((nf+2)/2) * W/nf * 0.18u' pd='2*int((nf+1)/2) * (W/nf + 0.18u)'
+ ps='2*int((nf+2)/2) * (W/nf + 0.18u)' nrd='0.18u / W' nrs='0.18u / W' sa=0 sb=0 sd=0 m=1
XRSLEWPDP DP_GATEP DP_PREP VSS ppolyf_u r_width=1u r_length=2u m=1
XMP3ADP DP_PX TXDP VDD VDD pfet_03v3 L=0.28u W=8u nf=1 ad='int((nf+1)/2) * W/nf * 0.18u' as='int((nf+2)/2) * W/nf * 0.18u' pd='2*int((nf+1)/2) * (W/nf + 0.18u)'
+ ps='2*int((nf+2)/2) * (W/nf + 0.18u)' nrd='0.18u / W' nrs='0.18u / W' sa=0 sb=0 sd=0 m=1
XMP3BDP DP_PREN TXOEB DP_PX VDD pfet_03v3 L=0.28u W=8u nf=1 ad='int((nf+1)/2) * W/nf * 0.18u' as='int((nf+2)/2) * W/nf * 0.18u' pd='2*int((nf+1)/2) * (W/nf + 0.18u)'
+ ps='2*int((nf+2)/2) * (W/nf + 0.18u)' nrd='0.18u / W' nrs='0.18u / W' sa=0 sb=0 sd=0 m=1
XMN3ADP DP_PREN TXDP VSS VSS nfet_03v3 L=0.28u W=2u nf=1 ad='int((nf+1)/2) * W/nf * 0.18u' as='int((nf+2)/2) * W/nf * 0.18u' pd='2*int((nf+1)/2) * (W/nf + 0.18u)'
+ ps='2*int((nf+2)/2) * (W/nf + 0.18u)' nrd='0.18u / W' nrs='0.18u / W' sa=0 sb=0 sd=0 m=1
XMN3BDP DP_PREN TXOEB VSS VSS nfet_03v3 L=0.28u W=2u nf=1 ad='int((nf+1)/2) * W/nf * 0.18u' as='int((nf+2)/2) * W/nf * 0.18u' pd='2*int((nf+1)/2) * (W/nf + 0.18u)'
+ ps='2*int((nf+2)/2) * (W/nf + 0.18u)' nrd='0.18u / W' nrs='0.18u / W' sa=0 sb=0 sd=0 m=1
XRSLEWNDP DP_GATEN DP_PREN VSS ppolyf_u r_width=1u r_length=2u m=1
XMP2DP DP_OUTINT DP_GATEP VDD VDD pfet_03v3 L=0.28u W=60u nf=1 ad='int((nf+1)/2) * W/nf * 0.18u' as='int((nf+2)/2) * W/nf * 0.18u'
+ pd='2*int((nf+1)/2) * (W/nf + 0.18u)' ps='2*int((nf+2)/2) * (W/nf + 0.18u)' nrd='0.18u / W' nrs='0.18u / W' sa=0 sb=0 sd=0 m=1
XMN2DP DP_OUTINT DP_GATEN VSS VSS nfet_03v3 L=0.28u W=30u nf=1 ad='int((nf+1)/2) * W/nf * 0.18u' as='int((nf+2)/2) * W/nf * 0.18u'
+ pd='2*int((nf+1)/2) * (W/nf + 0.18u)' ps='2*int((nf+2)/2) * (W/nf + 0.18u)' nrd='0.18u / W' nrs='0.18u / W' sa=0 sb=0 sd=0 m=1
XRSERDP DP DP_OUTINT rm1 r_width=2u r_length=800u m=1
XMP1ADM DM_PREP TXDM VDD VDD pfet_03v3 L=0.28u W=4u nf=1 ad='int((nf+1)/2) * W/nf * 0.18u' as='int((nf+2)/2) * W/nf * 0.18u' pd='2*int((nf+1)/2) * (W/nf + 0.18u)'
+ ps='2*int((nf+2)/2) * (W/nf + 0.18u)' nrd='0.18u / W' nrs='0.18u / W' sa=0 sb=0 sd=0 m=1
XMP1BDM DM_PREP TXOE VDD VDD pfet_03v3 L=0.28u W=4u nf=1 ad='int((nf+1)/2) * W/nf * 0.18u' as='int((nf+2)/2) * W/nf * 0.18u' pd='2*int((nf+1)/2) * (W/nf + 0.18u)'
+ ps='2*int((nf+2)/2) * (W/nf + 0.18u)' nrd='0.18u / W' nrs='0.18u / W' sa=0 sb=0 sd=0 m=1
XMN1ADM DM_PREP TXDM DM_NX VSS nfet_03v3 L=0.28u W=4u nf=1 ad='int((nf+1)/2) * W/nf * 0.18u' as='int((nf+2)/2) * W/nf * 0.18u' pd='2*int((nf+1)/2) * (W/nf + 0.18u)'
+ ps='2*int((nf+2)/2) * (W/nf + 0.18u)' nrd='0.18u / W' nrs='0.18u / W' sa=0 sb=0 sd=0 m=1
XMN1BDM DM_NX TXOE VSS VSS nfet_03v3 L=0.28u W=4u nf=1 ad='int((nf+1)/2) * W/nf * 0.18u' as='int((nf+2)/2) * W/nf * 0.18u' pd='2*int((nf+1)/2) * (W/nf + 0.18u)'
+ ps='2*int((nf+2)/2) * (W/nf + 0.18u)' nrd='0.18u / W' nrs='0.18u / W' sa=0 sb=0 sd=0 m=1
XRSLEWPDM DM_GATEP DM_PREP VSS ppolyf_u r_width=1u r_length=2u m=1
XMP3ADM DM_PX TXDM VDD VDD pfet_03v3 L=0.28u W=8u nf=1 ad='int((nf+1)/2) * W/nf * 0.18u' as='int((nf+2)/2) * W/nf * 0.18u' pd='2*int((nf+1)/2) * (W/nf + 0.18u)'
+ ps='2*int((nf+2)/2) * (W/nf + 0.18u)' nrd='0.18u / W' nrs='0.18u / W' sa=0 sb=0 sd=0 m=1
XMP3BDM DM_PREN TXOEB DM_PX VDD pfet_03v3 L=0.28u W=8u nf=1 ad='int((nf+1)/2) * W/nf * 0.18u' as='int((nf+2)/2) * W/nf * 0.18u' pd='2*int((nf+1)/2) * (W/nf + 0.18u)'
+ ps='2*int((nf+2)/2) * (W/nf + 0.18u)' nrd='0.18u / W' nrs='0.18u / W' sa=0 sb=0 sd=0 m=1
XMN3ADM DM_PREN TXDM VSS VSS nfet_03v3 L=0.28u W=2u nf=1 ad='int((nf+1)/2) * W/nf * 0.18u' as='int((nf+2)/2) * W/nf * 0.18u' pd='2*int((nf+1)/2) * (W/nf + 0.18u)'
+ ps='2*int((nf+2)/2) * (W/nf + 0.18u)' nrd='0.18u / W' nrs='0.18u / W' sa=0 sb=0 sd=0 m=1
XMN3BDM DM_PREN TXOEB VSS VSS nfet_03v3 L=0.28u W=2u nf=1 ad='int((nf+1)/2) * W/nf * 0.18u' as='int((nf+2)/2) * W/nf * 0.18u' pd='2*int((nf+1)/2) * (W/nf + 0.18u)'
+ ps='2*int((nf+2)/2) * (W/nf + 0.18u)' nrd='0.18u / W' nrs='0.18u / W' sa=0 sb=0 sd=0 m=1
XRSLEWNDM DM_GATEN DM_PREN VSS ppolyf_u r_width=1u r_length=2u m=1
XMP2DM DM_OUTINT DM_GATEP VDD VDD pfet_03v3 L=0.28u W=60u nf=1 ad='int((nf+1)/2) * W/nf * 0.18u' as='int((nf+2)/2) * W/nf * 0.18u'
+ pd='2*int((nf+1)/2) * (W/nf + 0.18u)' ps='2*int((nf+2)/2) * (W/nf + 0.18u)' nrd='0.18u / W' nrs='0.18u / W' sa=0 sb=0 sd=0 m=1
XMN2DM DM_OUTINT DM_GATEN VSS VSS nfet_03v3 L=0.28u W=30u nf=1 ad='int((nf+1)/2) * W/nf * 0.18u' as='int((nf+2)/2) * W/nf * 0.18u'
+ pd='2*int((nf+1)/2) * (W/nf + 0.18u)' ps='2*int((nf+2)/2) * (W/nf + 0.18u)' nrd='0.18u / W' nrs='0.18u / W' sa=0 sb=0 sd=0 m=1
XRSERDM DM DM_OUTINT rm1 r_width=2u r_length=800u m=1
.ends
