* driver-jitter -- driver-output edge timing across a full-speed bit pattern
*
* Netlist FRAGMENT. The harness supplies the title, the .include of the
* gf180mcu models, the corner .lib sections, .temp, the .control block and
* .end. Parameters provided by the harness: vdd_val, vdd_nom, temp_c.
*
* DUT: design/netlist/differential_driver.spice (named by tb.json's "dut"),
* the schematic-level export of design/differential_driver.sch.
*
* What this substantiates (spec/usb2-device-phy.md):
*   §8.2 row "Driver-output timing jitter | Derived budget, see note below |
*        Transient simulation, edge-to-edge timing variation across the corner
*        set".
*
* IMPORTANT -- this record carries NO pass/fail against a spec number, and
* that is the ratified instruction, not an omission. §8.2's jitter note says
* the repo does not have confirmed numeric source-jitter limits from the
* physical USB 2.0 text, that inventing "plausible-sounding nanosecond
* figures" is forbidden, and that "until that pull happens, sim/ may record
* measured jitter as engineering data without a spec citation attached".
* So tb.json declares no min/max limits on any jitter measurement. The only
* check present is a harness-integrity spread floor on the propagation delay,
* which asserts the corner sweep actually moved -- it is not a spec claim.
*
* Stimulus: an 18-bit line-level pattern at the ratified 12 Mbps full-speed
* bit rate (bit time 83.333 ns), with run lengths 1,1,2,1,3,1,6,1,2. The
* varied run lengths are the point: a periodic square wave gives every edge an
* identical history and would report zero data-dependent jitter by
* construction. The longest run is 6 bits, which is the longest line-level run
* USB full-speed produces before bit stuffing forces a transition. Bit
* boundaries sit at 200 ns + k x 83.333 ns, so the eight differential
* transitions land at bit indices 1, 2, 4, 5, 8, 9, 15, 16 -- offsets
* 0, 1, 3, 4, 7, 8, 14, 15 bit times from the first one.
*
* Measured quantity: the time at which D+ and D- cross, for each of the eight
* transitions, compared against an ideal bit grid anchored on the *first*
* crossing (so the driver's own propagation delay, reported separately, does
* not masquerade as jitter). Load is the same 50 pF per line the §6 test load
* ratifies, so these numbers sit on the same footing as the rise/fall record.

.csparam tbit={83.3333333e-9}

vsup VDD 0 dc {vdd_val}

vtxdp TXDP 0 pwl(0.0000n {vdd_val} 283.3333n {vdd_val} 284.3333n 0 366.6667n 0
+ 367.6667n {vdd_val} 533.3333n {vdd_val} 534.3333n 0 616.6667n 0
+ 617.6667n {vdd_val} 866.6667n {vdd_val} 867.6667n 0 950.0000n 0
+ 951.0000n {vdd_val} 1450.0000n {vdd_val} 1451.0000n 0 1533.3333n 0
+ 1534.3333n {vdd_val} 1700.0000n {vdd_val})

vtxdm TXDM 0 pwl(0.0000n 0 283.3333n 0 284.3333n {vdd_val} 366.6667n {vdd_val}
+ 367.6667n 0 533.3333n 0 534.3333n {vdd_val} 616.6667n {vdd_val}
+ 617.6667n 0 866.6667n 0 867.6667n {vdd_val} 950.0000n {vdd_val}
+ 951.0000n 0 1450.0000n 0 1451.0000n {vdd_val} 1533.3333n {vdd_val}
+ 1534.3333n 0 1700.0000n 0)

Xdrv VDD 0 TXDP TXDM DP DM differential_driver

cdp DP 0 50p
cdm DM 0 50p
