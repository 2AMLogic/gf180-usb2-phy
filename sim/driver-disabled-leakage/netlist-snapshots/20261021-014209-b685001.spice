* Frozen netlist snapshot for record 20261021-014209-b685001
* source     : sim/driver-disabled-leakage/testbench/driver_disabled_tb.spice
* sha256     : 7aadb681fa272ea8658d92d506cfbc281ba34264461681841b1e6749865eaf91
* This is a verbatim copy taken at record time. Do not edit.
* driver-disabled-leakage -- differential driver with TXOE low on an externally driven bus
*
* Netlist FRAGMENT. The harness supplies the title, the .include of the
* gf180mcu models, the corner .lib sections, .temp, the .control block and
* .end. Parameters provided by the harness: vdd_val, vdd_nom, temp_c.
*
* DUT: design/netlist/differential_driver.spice (tb.json "dut").
*
* What this measures (issue #114; DR-0004 pin TXOE). The driver cell has an
* active-high TXOE; TXOE=0 must make DP and DM high-Z. Here an IDEAL voltage
* source on each pad plays "the host owns the bus" and the current into that
* source is the leakage. The 50 pF §6 test load of driver-signal-quality is
* NOT present: this setup is separate on purpose.
*
* Spec context: spec/usb2-device-phy.md has no numeric leakage or high-Z
* current row, and this repo has not adopted a bound, so NO limit is attached
* to any leakage number. They are engineering data. The one check present is
* a harness-integrity check on the deliberately-enabled contention control
* (the current meter must be able to see a fight).
*
* Timeline (ns). Pad sources drive 3.3 V (fixed, NOT vdd_val: at the 2.97 V
* supply corner a 3.3 V host exceeds the PHY supply, the stressful case; at
* 3.63 V it is below it).
*   blocks 0..3, 200 ns each, TXOE=0: pad state SE0 (0,0 V), J (DP 3.3, DM 0),
*     K (DP 0, DM 3.3), SE1 (3.3, 3.3). Pad edge at each block start. Within a
*     block the 50 ns slots drive TXDP/TXDM through 00, 01, 10, 11, so all four
*     input-data combinations meet every pad state and the inputs toggle while
*     disabled. Settled leakage = last 20 ns of each slot.
*   800-1000   CONTENTION CONTROL: TXOE=1, TXDP=1, TXDM=0 against sources
*     holding DP=0 V, DM=3.3 V. Tail = last 40 ns.
*   1000-1100  TXOE=0 with the pad sources at DP=3.3, DM=0 (disable release).
*   1100-1200, 1300-1350  TXOE=1, TXDP=1, TXDM=0 matching the bus (no fight):
*     enable transitions; 1200-1300 and 1350-1400 disabled again.

vsup VDD 0 dc {vdd_val}
vdp DP 0 pwl(0n 0 200n 0 200.5n 3.3 400n 3.3 400.5n 0 600n 0 600.5n 3.3 800n 3.3 800.5n 0 1000n 0 1000.5n 3.3)
vdm DM 0 pwl(0n 0 400n 0 400.5n 3.3 1000n 3.3 1000.5n 0)
vtxdp TXDP 0 pwl(0n 0 100n 0 100.5n {vdd_val} 200n {vdd_val} 200.5n 0 300n 0 300.5n {vdd_val} 400n {vdd_val} 400.5n 0 500n 0 500.5n {vdd_val} 600n {vdd_val} 600.5n 0 700n 0 700.5n {vdd_val})
vtxdm TXDM 0 pwl(0n 0 50n 0 50.5n {vdd_val} 100n {vdd_val} 100.5n 0 150n 0 150.5n {vdd_val} 200n {vdd_val} 200.5n 0 250n 0 250.5n {vdd_val} 300n {vdd_val} 300.5n 0 350n 0 350.5n {vdd_val} 400n {vdd_val} 400.5n 0 450n 0 450.5n {vdd_val} 500n {vdd_val} 500.5n 0 550n 0 550.5n {vdd_val} 600n {vdd_val} 600.5n 0 650n 0 650.5n {vdd_val} 700n {vdd_val} 700.5n 0 750n 0 750.5n {vdd_val} 800n {vdd_val} 800.5n 0)
vtxoe TXOE 0 pwl(0n 0 800n 0 800.5n {vdd_val} 1000n {vdd_val} 1000.5n 0 1100n 0 1100.5n {vdd_val} 1200n {vdd_val} 1200.5n 0 1300n 0 1300.5n {vdd_val} 1350n {vdd_val} 1350.5n 0)

Xdrv VDD 0 TXDP TXDM TXOE DP DM differential_driver

* Windowing signals for the .meas cards (gt: settled tail of a 50 ns slot).
bgt gt 0 v=(time-50n*floor(time/50n)>=30n)
* slot index within a 200 ns block: 0 has the pad edge, 1..3 are pure data toggles
bgs gs 0 v=(time-200n*floor(time/200n)>=50n)
bw_se0_dp w_se0_dp 0 v=abs(i(vdp))*v(gt)*(time>=0n)*(time<200n)
bw_se0_dm w_se0_dm 0 v=abs(i(vdm))*v(gt)*(time>=0n)*(time<200n)
bw_j_dp w_j_dp 0 v=abs(i(vdp))*v(gt)*(time>=200n)*(time<400n)
bw_j_dm w_j_dm 0 v=abs(i(vdm))*v(gt)*(time>=200n)*(time<400n)
bw_k_dp w_k_dp 0 v=abs(i(vdp))*v(gt)*(time>=400n)*(time<600n)
bw_k_dm w_k_dm 0 v=abs(i(vdm))*v(gt)*(time>=400n)*(time<600n)
bw_se1_dp w_se1_dp 0 v=abs(i(vdp))*v(gt)*(time>=600n)*(time<800n)
bw_se1_dm w_se1_dm 0 v=abs(i(vdm))*v(gt)*(time>=600n)*(time<800n)
bw_all w_all 0 v=max(abs(i(vdp)),abs(i(vdm)))*v(gt)*(time<800n)
bw_tog_dp w_tog_dp 0 v=abs(i(vdp))*v(gs)*(time<800n)
bw_con_dp w_con_dp 0 v=abs(i(vdp))*(time>=960n)*(time<1000n)
bw_tog_dm w_tog_dm 0 v=abs(i(vdm))*v(gs)*(time<800n)
bw_con_dm w_con_dm 0 v=abs(i(vdm))*(time>=960n)*(time<1000n)
bw_rel w_rel 0 v=max(abs(i(vdp)),abs(i(vdm)))*((time>=1070n)*(time<1100n)+(time>=1270n)*(time<1300n)+(time>=1370n)*(time<1400n))
bw_en w_en 0 v=max(abs(i(vdp)),abs(i(vdm)))*((time>=1160n)*(time<1200n)+(time>=1335n)*(time<1350n))
bw_trn w_trn 0 v=max(abs(i(vdp)),abs(i(vdm)))*((time>=1100n)*(time<1160n)+(time>=1200n)*(time<1260n)+(time>=1300n)*(time<1335n)+(time>=1350n)*(time<1360n))

* ---------------------------------------------------------------
* DUT netlist included by this testbench (schematic)
* source     : design/netlist/differential_driver.spice
* sha256     : 50dcbc20ca353357ffeaf63b347f5b76e218625921035e0c6c1692413b9a8930
* ---------------------------------------------------------------

* differential_driver -- generated by design/netlist.py from design/differential_driver.sch
* Do not edit: edit the schematic and re-run the export.
** sch_path: design/differential_driver.sch
.subckt differential_driver VDD VSS TXDP TXDM TXOE DP DM
*.PININFO VDD:B VSS:B TXDP:I TXDM:I TXOE:I DP:B DM:B
XMPOEB TXOEB TXOE VDD VDD pfet_03v3 L=0.28u W=4u nf=1 ad='int((nf+1)/2) * W/nf * 0.18u' as='int((nf+2)/2) * W/nf * 0.18u' pd='2*int((nf+1)/2) * (W/nf + 0.18u)'
+ ps='2*int((nf+2)/2) * (W/nf + 0.18u)' nrd='0.18u / W' nrs='0.18u / W' sa=0 sb=0 sd=0 m=1
XMNOEB TXOEB TXOE VSS VSS nfet_03v3 L=0.28u W=2u nf=1 ad='int((nf+1)/2) * W/nf * 0.18u' as='int((nf+2)/2) * W/nf * 0.18u' pd='2*int((nf+1)/2) * (W/nf + 0.18u)'
+ ps='2*int((nf+2)/2) * (W/nf + 0.18u)' nrd='0.18u / W' nrs='0.18u / W' sa=0 sb=0 sd=0 m=1
XMP1ADP DP_PREP TXDP VDD VDD pfet_03v3 L=0.28u W=8u nf=1 ad='int((nf+1)/2) * W/nf * 0.18u' as='int((nf+2)/2) * W/nf * 0.18u' pd='2*int((nf+1)/2) * (W/nf + 0.18u)'
+ ps='2*int((nf+2)/2) * (W/nf + 0.18u)' nrd='0.18u / W' nrs='0.18u / W' sa=0 sb=0 sd=0 m=1
XMP1BDP DP_PREP TXOE VDD VDD pfet_03v3 L=0.28u W=8u nf=1 ad='int((nf+1)/2) * W/nf * 0.18u' as='int((nf+2)/2) * W/nf * 0.18u' pd='2*int((nf+1)/2) * (W/nf + 0.18u)'
+ ps='2*int((nf+2)/2) * (W/nf + 0.18u)' nrd='0.18u / W' nrs='0.18u / W' sa=0 sb=0 sd=0 m=1
XMN1ADP DP_PREP TXDP DP_NX VSS nfet_03v3 L=0.28u W=5u nf=1 ad='int((nf+1)/2) * W/nf * 0.18u' as='int((nf+2)/2) * W/nf * 0.18u' pd='2*int((nf+1)/2) * (W/nf + 0.18u)'
+ ps='2*int((nf+2)/2) * (W/nf + 0.18u)' nrd='0.18u / W' nrs='0.18u / W' sa=0 sb=0 sd=0 m=1
XMN1BDP DP_NX TXOE VSS VSS nfet_03v3 L=0.28u W=5u nf=1 ad='int((nf+1)/2) * W/nf * 0.18u' as='int((nf+2)/2) * W/nf * 0.18u' pd='2*int((nf+1)/2) * (W/nf + 0.18u)'
+ ps='2*int((nf+2)/2) * (W/nf + 0.18u)' nrd='0.18u / W' nrs='0.18u / W' sa=0 sb=0 sd=0 m=1
XRSLEWPDP DP_GATEP DP_PREP VSS ppolyf_u r_width=1u r_length=2u m=1
XMP3ADP DP_PX TXDP VDD VDD pfet_03v3 L=0.28u W=16u nf=1 ad='int((nf+1)/2) * W/nf * 0.18u' as='int((nf+2)/2) * W/nf * 0.18u' pd='2*int((nf+1)/2) * (W/nf + 0.18u)'
+ ps='2*int((nf+2)/2) * (W/nf + 0.18u)' nrd='0.18u / W' nrs='0.18u / W' sa=0 sb=0 sd=0 m=1
XMP3BDP DP_PREN TXOEB DP_PX VDD pfet_03v3 L=0.28u W=16u nf=1 ad='int((nf+1)/2) * W/nf * 0.18u' as='int((nf+2)/2) * W/nf * 0.18u'
+ pd='2*int((nf+1)/2) * (W/nf + 0.18u)' ps='2*int((nf+2)/2) * (W/nf + 0.18u)' nrd='0.18u / W' nrs='0.18u / W' sa=0 sb=0 sd=0 m=1
XMN3ADP DP_PREN TXDP VSS VSS nfet_03v3 L=0.28u W=2.5u nf=1 ad='int((nf+1)/2) * W/nf * 0.18u' as='int((nf+2)/2) * W/nf * 0.18u' pd='2*int((nf+1)/2) * (W/nf + 0.18u)'
+ ps='2*int((nf+2)/2) * (W/nf + 0.18u)' nrd='0.18u / W' nrs='0.18u / W' sa=0 sb=0 sd=0 m=1
XMN3BDP DP_PREN TXOEB VSS VSS nfet_03v3 L=0.28u W=2.5u nf=1 ad='int((nf+1)/2) * W/nf * 0.18u' as='int((nf+2)/2) * W/nf * 0.18u' pd='2*int((nf+1)/2) * (W/nf + 0.18u)'
+ ps='2*int((nf+2)/2) * (W/nf + 0.18u)' nrd='0.18u / W' nrs='0.18u / W' sa=0 sb=0 sd=0 m=1
XRSLEWNDP DP_GATEN DP_PREN VSS ppolyf_u r_width=1u r_length=2u m=1
XMP2DP_1 DP_OUTINT DP_GATEP VDD VDD pfet_03v3 L=0.28u W=80u nf=1 ad='int((nf+1)/2) * W/nf * 0.18u' as='int((nf+2)/2) * W/nf * 0.18u'
+ pd='2*int((nf+1)/2) * (W/nf + 0.18u)' ps='2*int((nf+2)/2) * (W/nf + 0.18u)' nrd='0.18u / W' nrs='0.18u / W' sa=0 sb=0 sd=0 m=1
XMP2DP_2 DP_OUTINT DP_GATEP VDD VDD pfet_03v3 L=0.28u W=80u nf=1 ad='int((nf+1)/2) * W/nf * 0.18u' as='int((nf+2)/2) * W/nf * 0.18u'
+ pd='2*int((nf+1)/2) * (W/nf + 0.18u)' ps='2*int((nf+2)/2) * (W/nf + 0.18u)' nrd='0.18u / W' nrs='0.18u / W' sa=0 sb=0 sd=0 m=1
XMP2DP_3 DP_OUTINT DP_GATEP VDD VDD pfet_03v3 L=0.28u W=80u nf=1 ad='int((nf+1)/2) * W/nf * 0.18u' as='int((nf+2)/2) * W/nf * 0.18u'
+ pd='2*int((nf+1)/2) * (W/nf + 0.18u)' ps='2*int((nf+2)/2) * (W/nf + 0.18u)' nrd='0.18u / W' nrs='0.18u / W' sa=0 sb=0 sd=0 m=1
XMP2DP_4 DP_OUTINT DP_GATEP VDD VDD pfet_03v3 L=0.28u W=80u nf=1 ad='int((nf+1)/2) * W/nf * 0.18u' as='int((nf+2)/2) * W/nf * 0.18u'
+ pd='2*int((nf+1)/2) * (W/nf + 0.18u)' ps='2*int((nf+2)/2) * (W/nf + 0.18u)' nrd='0.18u / W' nrs='0.18u / W' sa=0 sb=0 sd=0 m=1
XMN2DP_1 DP_OUTINT DP_GATEN VSS VSS nfet_03v3 L=0.28u W=30u nf=1 ad='int((nf+1)/2) * W/nf * 0.18u' as='int((nf+2)/2) * W/nf * 0.18u'
+ pd='2*int((nf+1)/2) * (W/nf + 0.18u)' ps='2*int((nf+2)/2) * (W/nf + 0.18u)' nrd='0.18u / W' nrs='0.18u / W' sa=0 sb=0 sd=0 m=1
XMN2DP_2 DP_OUTINT DP_GATEN VSS VSS nfet_03v3 L=0.28u W=30u nf=1 ad='int((nf+1)/2) * W/nf * 0.18u' as='int((nf+2)/2) * W/nf * 0.18u'
+ pd='2*int((nf+1)/2) * (W/nf + 0.18u)' ps='2*int((nf+2)/2) * (W/nf + 0.18u)' nrd='0.18u / W' nrs='0.18u / W' sa=0 sb=0 sd=0 m=1
XMN2DP_3 DP_OUTINT DP_GATEN VSS VSS nfet_03v3 L=0.28u W=30u nf=1 ad='int((nf+1)/2) * W/nf * 0.18u' as='int((nf+2)/2) * W/nf * 0.18u'
+ pd='2*int((nf+1)/2) * (W/nf + 0.18u)' ps='2*int((nf+2)/2) * (W/nf + 0.18u)' nrd='0.18u / W' nrs='0.18u / W' sa=0 sb=0 sd=0 m=1
XMN2DP_4 DP_OUTINT DP_GATEN VSS VSS nfet_03v3 L=0.28u W=30u nf=1 ad='int((nf+1)/2) * W/nf * 0.18u' as='int((nf+2)/2) * W/nf * 0.18u'
+ pd='2*int((nf+1)/2) * (W/nf + 0.18u)' ps='2*int((nf+2)/2) * (W/nf + 0.18u)' nrd='0.18u / W' nrs='0.18u / W' sa=0 sb=0 sd=0 m=1
XRSERDP DP DP_OUTINT rm1 r_width=2u r_length=800u m=1
XMP1ADM DM_PREP TXDM VDD VDD pfet_03v3 L=0.28u W=8u nf=1 ad='int((nf+1)/2) * W/nf * 0.18u' as='int((nf+2)/2) * W/nf * 0.18u' pd='2*int((nf+1)/2) * (W/nf + 0.18u)'
+ ps='2*int((nf+2)/2) * (W/nf + 0.18u)' nrd='0.18u / W' nrs='0.18u / W' sa=0 sb=0 sd=0 m=1
XMP1BDM DM_PREP TXOE VDD VDD pfet_03v3 L=0.28u W=8u nf=1 ad='int((nf+1)/2) * W/nf * 0.18u' as='int((nf+2)/2) * W/nf * 0.18u' pd='2*int((nf+1)/2) * (W/nf + 0.18u)'
+ ps='2*int((nf+2)/2) * (W/nf + 0.18u)' nrd='0.18u / W' nrs='0.18u / W' sa=0 sb=0 sd=0 m=1
XMN1ADM DM_PREP TXDM DM_NX VSS nfet_03v3 L=0.28u W=5u nf=1 ad='int((nf+1)/2) * W/nf * 0.18u' as='int((nf+2)/2) * W/nf * 0.18u' pd='2*int((nf+1)/2) * (W/nf + 0.18u)'
+ ps='2*int((nf+2)/2) * (W/nf + 0.18u)' nrd='0.18u / W' nrs='0.18u / W' sa=0 sb=0 sd=0 m=1
XMN1BDM DM_NX TXOE VSS VSS nfet_03v3 L=0.28u W=5u nf=1 ad='int((nf+1)/2) * W/nf * 0.18u' as='int((nf+2)/2) * W/nf * 0.18u' pd='2*int((nf+1)/2) * (W/nf + 0.18u)'
+ ps='2*int((nf+2)/2) * (W/nf + 0.18u)' nrd='0.18u / W' nrs='0.18u / W' sa=0 sb=0 sd=0 m=1
XRSLEWPDM DM_GATEP DM_PREP VSS ppolyf_u r_width=1u r_length=2u m=1
XMP3ADM DM_PX TXDM VDD VDD pfet_03v3 L=0.28u W=16u nf=1 ad='int((nf+1)/2) * W/nf * 0.18u' as='int((nf+2)/2) * W/nf * 0.18u' pd='2*int((nf+1)/2) * (W/nf + 0.18u)'
+ ps='2*int((nf+2)/2) * (W/nf + 0.18u)' nrd='0.18u / W' nrs='0.18u / W' sa=0 sb=0 sd=0 m=1
XMP3BDM DM_PREN TXOEB DM_PX VDD pfet_03v3 L=0.28u W=16u nf=1 ad='int((nf+1)/2) * W/nf * 0.18u' as='int((nf+2)/2) * W/nf * 0.18u'
+ pd='2*int((nf+1)/2) * (W/nf + 0.18u)' ps='2*int((nf+2)/2) * (W/nf + 0.18u)' nrd='0.18u / W' nrs='0.18u / W' sa=0 sb=0 sd=0 m=1
XMN3ADM DM_PREN TXDM VSS VSS nfet_03v3 L=0.28u W=2.5u nf=1 ad='int((nf+1)/2) * W/nf * 0.18u' as='int((nf+2)/2) * W/nf * 0.18u' pd='2*int((nf+1)/2) * (W/nf + 0.18u)'
+ ps='2*int((nf+2)/2) * (W/nf + 0.18u)' nrd='0.18u / W' nrs='0.18u / W' sa=0 sb=0 sd=0 m=1
XMN3BDM DM_PREN TXOEB VSS VSS nfet_03v3 L=0.28u W=2.5u nf=1 ad='int((nf+1)/2) * W/nf * 0.18u' as='int((nf+2)/2) * W/nf * 0.18u' pd='2*int((nf+1)/2) * (W/nf + 0.18u)'
+ ps='2*int((nf+2)/2) * (W/nf + 0.18u)' nrd='0.18u / W' nrs='0.18u / W' sa=0 sb=0 sd=0 m=1
XRSLEWNDM DM_GATEN DM_PREN VSS ppolyf_u r_width=1u r_length=2u m=1
XMP2DM_1 DM_OUTINT DM_GATEP VDD VDD pfet_03v3 L=0.28u W=80u nf=1 ad='int((nf+1)/2) * W/nf * 0.18u' as='int((nf+2)/2) * W/nf * 0.18u'
+ pd='2*int((nf+1)/2) * (W/nf + 0.18u)' ps='2*int((nf+2)/2) * (W/nf + 0.18u)' nrd='0.18u / W' nrs='0.18u / W' sa=0 sb=0 sd=0 m=1
XMP2DM_2 DM_OUTINT DM_GATEP VDD VDD pfet_03v3 L=0.28u W=80u nf=1 ad='int((nf+1)/2) * W/nf * 0.18u' as='int((nf+2)/2) * W/nf * 0.18u'
+ pd='2*int((nf+1)/2) * (W/nf + 0.18u)' ps='2*int((nf+2)/2) * (W/nf + 0.18u)' nrd='0.18u / W' nrs='0.18u / W' sa=0 sb=0 sd=0 m=1
XMP2DM_3 DM_OUTINT DM_GATEP VDD VDD pfet_03v3 L=0.28u W=80u nf=1 ad='int((nf+1)/2) * W/nf * 0.18u' as='int((nf+2)/2) * W/nf * 0.18u'
+ pd='2*int((nf+1)/2) * (W/nf + 0.18u)' ps='2*int((nf+2)/2) * (W/nf + 0.18u)' nrd='0.18u / W' nrs='0.18u / W' sa=0 sb=0 sd=0 m=1
XMP2DM_4 DM_OUTINT DM_GATEP VDD VDD pfet_03v3 L=0.28u W=80u nf=1 ad='int((nf+1)/2) * W/nf * 0.18u' as='int((nf+2)/2) * W/nf * 0.18u'
+ pd='2*int((nf+1)/2) * (W/nf + 0.18u)' ps='2*int((nf+2)/2) * (W/nf + 0.18u)' nrd='0.18u / W' nrs='0.18u / W' sa=0 sb=0 sd=0 m=1
XMN2DM_1 DM_OUTINT DM_GATEN VSS VSS nfet_03v3 L=0.28u W=30u nf=1 ad='int((nf+1)/2) * W/nf * 0.18u' as='int((nf+2)/2) * W/nf * 0.18u'
+ pd='2*int((nf+1)/2) * (W/nf + 0.18u)' ps='2*int((nf+2)/2) * (W/nf + 0.18u)' nrd='0.18u / W' nrs='0.18u / W' sa=0 sb=0 sd=0 m=1
XMN2DM_2 DM_OUTINT DM_GATEN VSS VSS nfet_03v3 L=0.28u W=30u nf=1 ad='int((nf+1)/2) * W/nf * 0.18u' as='int((nf+2)/2) * W/nf * 0.18u'
+ pd='2*int((nf+1)/2) * (W/nf + 0.18u)' ps='2*int((nf+2)/2) * (W/nf + 0.18u)' nrd='0.18u / W' nrs='0.18u / W' sa=0 sb=0 sd=0 m=1
XMN2DM_3 DM_OUTINT DM_GATEN VSS VSS nfet_03v3 L=0.28u W=30u nf=1 ad='int((nf+1)/2) * W/nf * 0.18u' as='int((nf+2)/2) * W/nf * 0.18u'
+ pd='2*int((nf+1)/2) * (W/nf + 0.18u)' ps='2*int((nf+2)/2) * (W/nf + 0.18u)' nrd='0.18u / W' nrs='0.18u / W' sa=0 sb=0 sd=0 m=1
XMN2DM_4 DM_OUTINT DM_GATEN VSS VSS nfet_03v3 L=0.28u W=30u nf=1 ad='int((nf+1)/2) * W/nf * 0.18u' as='int((nf+2)/2) * W/nf * 0.18u'
+ pd='2*int((nf+1)/2) * (W/nf + 0.18u)' ps='2*int((nf+2)/2) * (W/nf + 0.18u)' nrd='0.18u / W' nrs='0.18u / W' sa=0 sb=0 sd=0 m=1
XRSERDM DM DM_OUTINT rm1 r_width=2u r_length=800u m=1
.ends
