* Frozen netlist snapshot for record 20260817-203631-a408cb6
* source     : sim/se-receiver-dp-thresholds/testbench/se_rx_dp_tb.spice
* sha256     : bcacba3cc4a12b6335896577c12c2380c0acaa9e060f30e58f0288c94a244347
* This is a verbatim copy taken at record time. Do not edit.
* se-receiver-dp-thresholds -- single-ended D+ receiver switching levels vs. §4
*
* Netlist FRAGMENT. The harness supplies the title, the .include of the
* gf180mcu models, the corner .lib sections, .temp, the .control block and
* .end. Parameters provided by the harness: vdd_val, vdd_nom, temp_c.
*
* DUT: design/netlist/se_receiver_dp.spice (named by tb.json's "dut"), the
* schematic-level export of design/se_receiver_dp.sch.
*
* What this substantiates (spec/usb2-device-phy.md):
*   §4   single-ended receiver on D+: VIH > 2.0 V, VIL < 0.8 V
*   §8.2 "Receiver thresholds ... DC/parametric analysis across the 45 corners"
*        (D+ single-ended half; the D− receiver is a separate schematic and
*        gets its own experiment, sim/se-receiver-dm-thresholds/)
*
* Reading of the row: "VIH > 2.0 V, VIL < 0.8 V" means an input at or above
* 2.0 V is guaranteed to read high and an input at or below 0.8 V is guaranteed
* to read low. Equivalently the switching threshold must sit strictly inside
* (0.8 V, 2.0 V) *and* the output must be a valid logic level -- not merely
* past mid-rail -- at those two input voltages. Both halves are measured.
*
* Method: one DC sweep of the input from 0 V to 2.9 V. 2.9 V is the top of the
* sweep because the lowest supply on the §8.1 grid is 2.97 V, so the sweep
* never drives the input above its own rail while still covering the whole
* 0.8-2.0 V decision window with margin.
*
* .csparam publishes the per-corner logic midpoint into the control block so
* the threshold search follows the supply the harness set for this PVT point.

.csparam vmid={0.5*vdd_val}

vsup VDD 0 dc {vdd_val}
vin  IN  0 dc 0

Xrxdp VDD 0 IN RXDP se_receiver_dp

* ---------------------------------------------------------------
* DUT netlist included by this testbench (schematic)
* source     : design/netlist/se_receiver_dp.spice
* sha256     : 1f854210680331a1df73b96b317479cad4af325192fec68b0b61fb1421fac0b3
* ---------------------------------------------------------------

* se_receiver_dp -- generated by design/netlist.py from design/se_receiver_dp.sch
* Do not edit: edit the schematic and re-run the export.
** sch_path: design/se_receiver_dp.sch
.subckt se_receiver_dp VDD VSS DP RXDP
*.PININFO VDD:B VSS:B DP:I RXDP:B
XR1 VREF VDD VSS ppolyf_u_1k r_width=2u r_length=3.8u m=1
XR2 VSS VREF VSS ppolyf_u_1k r_width=2u r_length=2.8u m=1
XRBIAS IBIASN VDD VSS ppolyf_u_1k r_width=2u r_length=400u m=1
XMNBIAS IBIASN IBIASN VSS VSS nfet_03v3 L=0.5u W=4u nf=1 ad='int((nf+1)/2) * W/nf * 0.18u' as='int((nf+2)/2) * W/nf * 0.18u' pd='2*int((nf+1)/2) * (W/nf + 0.18u)'
+ ps='2*int((nf+2)/2) * (W/nf + 0.18u)' nrd='0.18u / W' nrs='0.18u / W' sa=0 sb=0 sd=0 m=1
XMTAIL TAIL IBIASN VSS VSS nfet_03v3 L=0.5u W=8u nf=1 ad='int((nf+1)/2) * W/nf * 0.18u' as='int((nf+2)/2) * W/nf * 0.18u' pd='2*int((nf+1)/2) * (W/nf + 0.18u)'
+ ps='2*int((nf+2)/2) * (W/nf + 0.18u)' nrd='0.18u / W' nrs='0.18u / W' sa=0 sb=0 sd=0 m=1
XMN_INA LOADDIODE DP TAIL VSS nfet_03v3 L=0.28u W=20u nf=1 ad='int((nf+1)/2) * W/nf * 0.18u' as='int((nf+2)/2) * W/nf * 0.18u' pd='2*int((nf+1)/2) * (W/nf + 0.18u)'
+ ps='2*int((nf+2)/2) * (W/nf + 0.18u)' nrd='0.18u / W' nrs='0.18u / W' sa=0 sb=0 sd=0 m=1
XMN_INB AMPOUT VREF TAIL VSS nfet_03v3 L=0.28u W=20u nf=1 ad='int((nf+1)/2) * W/nf * 0.18u' as='int((nf+2)/2) * W/nf * 0.18u' pd='2*int((nf+1)/2) * (W/nf + 0.18u)'
+ ps='2*int((nf+2)/2) * (W/nf + 0.18u)' nrd='0.18u / W' nrs='0.18u / W' sa=0 sb=0 sd=0 m=1
XMP_LOADA LOADDIODE LOADDIODE VDD VDD pfet_03v3 L=0.28u W=40u nf=1 ad='int((nf+1)/2) * W/nf * 0.18u' as='int((nf+2)/2) * W/nf * 0.18u'
+ pd='2*int((nf+1)/2) * (W/nf + 0.18u)' ps='2*int((nf+2)/2) * (W/nf + 0.18u)' nrd='0.18u / W' nrs='0.18u / W' sa=0 sb=0 sd=0 m=1
XMP_LOADB AMPOUT LOADDIODE VDD VDD pfet_03v3 L=0.28u W=40u nf=1 ad='int((nf+1)/2) * W/nf * 0.18u' as='int((nf+2)/2) * W/nf * 0.18u'
+ pd='2*int((nf+1)/2) * (W/nf + 0.18u)' ps='2*int((nf+2)/2) * (W/nf + 0.18u)' nrd='0.18u / W' nrs='0.18u / W' sa=0 sb=0 sd=0 m=1
XMP_B1 BUF1 AMPOUT VDD VDD pfet_03v3 L=0.28u W=8u nf=1 ad='int((nf+1)/2) * W/nf * 0.18u' as='int((nf+2)/2) * W/nf * 0.18u' pd='2*int((nf+1)/2) * (W/nf + 0.18u)'
+ ps='2*int((nf+2)/2) * (W/nf + 0.18u)' nrd='0.18u / W' nrs='0.18u / W' sa=0 sb=0 sd=0 m=1
XMN_B1 BUF1 AMPOUT VSS VSS nfet_03v3 L=0.28u W=4u nf=1 ad='int((nf+1)/2) * W/nf * 0.18u' as='int((nf+2)/2) * W/nf * 0.18u' pd='2*int((nf+1)/2) * (W/nf + 0.18u)'
+ ps='2*int((nf+2)/2) * (W/nf + 0.18u)' nrd='0.18u / W' nrs='0.18u / W' sa=0 sb=0 sd=0 m=1
XMP_B2 RXDP BUF1 VDD VDD pfet_03v3 L=0.28u W=16u nf=1 ad='int((nf+1)/2) * W/nf * 0.18u' as='int((nf+2)/2) * W/nf * 0.18u' pd='2*int((nf+1)/2) * (W/nf + 0.18u)'
+ ps='2*int((nf+2)/2) * (W/nf + 0.18u)' nrd='0.18u / W' nrs='0.18u / W' sa=0 sb=0 sd=0 m=1
XMN_B2 RXDP BUF1 VSS VSS nfet_03v3 L=0.28u W=8u nf=1 ad='int((nf+1)/2) * W/nf * 0.18u' as='int((nf+2)/2) * W/nf * 0.18u' pd='2*int((nf+1)/2) * (W/nf + 0.18u)'
+ ps='2*int((nf+2)/2) * (W/nf + 0.18u)' nrd='0.18u / W' nrs='0.18u / W' sa=0 sb=0 sd=0 m=1
.ends
