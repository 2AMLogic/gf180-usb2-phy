* se-receiver-thresholds -- single-ended receiver (any line) switching levels vs. §4
*
* Netlist FRAGMENT. The harness supplies the title, the .include of the
* gf180mcu models, the corner .lib sections, .temp, the .control block and
* .end. Parameters provided by the harness: vdd_val, vdd_nom, temp_c.
*
* DUT: design/netlist/se_receiver.spice (named by tb.json's "dut"), the
* schematic-level export of design/se_receiver.sch.
*
* What this substantiates (spec/usb2-device-phy.md):
*   §4   single-ended receiver: VIH > 2.0 V, VIL < 0.8 V
*   §8.2 "Receiver thresholds ... DC/parametric analysis across the 45 corners"
*        (one cell serves D+ and D-, DR-0011; it supersedes the per-line
*        benches sim/se-receiver-d{p,m}-thresholds/, which stay as records)
*
* Reading of the row: "VIH > 2.0 V, VIL < 0.8 V" means an input at or above
* 2.0 V is guaranteed to read high and an input at or below 0.8 V is guaranteed
* to read low. Equivalently the switching threshold must sit strictly inside
* (0.8 V, 2.0 V) *and* the output must be a valid logic level -- not merely
* past mid-rail -- at those two input voltages. Both halves are measured.
*
* Method: one DC sweep of the input from 0 V to 2.9 V. 2.9 V is the top of the
* sweep because the lowest supply on the §8.1 grid is 2.97 V, so the sweep
* never drives the input above its own rail while still covering the whole
* 0.8-2.0 V decision window with margin.
*
* .csparam publishes the per-corner logic midpoint into the control block so
* the threshold search follows the supply the harness set for this PVT point.

.csparam vmid={0.5*vdd_val}

vsup VDD 0 dc {vdd_val}
vin  IN  0 dc 0

* Reference nodes for the `klt sim` backend (tb.json "klt_measure"), which can
* only express measurements as `.meas` cards: the logic midpoint and the
* output normalised to the supply, both tracking whatever VDD `klt sim` alters
* the supply source to. The local-ngspice path ignores them.
bmid mid 0 v = 0.5*v(vdd)
bn1  n1  0 v = v(out)/v(vdd)

Xout VDD 0 IN OUT se_receiver
